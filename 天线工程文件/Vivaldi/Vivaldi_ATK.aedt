# Ansys Electronics Desktop project, version 2024.2
materials:
  vacuum: permittivity=1
  Duroid (tm): permittivity=2.2 dielectric_loss_tangent=0.0009
  copper: permeability=0.999991 conductivity=58000000
  pec: conductivity=1e+30

design Vivaldi_ATK (HFSS, HFSS Hybrid Terminal Network, model units cm)
options: Allow_Material_Override Save_Adaptive_support_files open_region{BoundaryType=0 OpFreq=14.5GHz}
variables:
  # --Antenna Dimensions
  Wslot = 0.02cm
  Lfeed = 0cm
  Wtaper = 1.87cm
  Ltapper = 3.75cm
  Wbalun = 0.35cm
  Lbalun = 0.35cm
  NumberOfPoints = 20
  # --Stripline Feed Dimensions
  Wstrip = 0.1328cm
  Lstrip = 0.5cm
  Lstrip_offset = 0.35cm
  feed_offset = 0cm
  # --Substrate Dimensions
  subH = 0.1575cm
  subX = 3.75cm
  subY = 4.6cm
geometry:
  VivaldiUDM1 = component(Wslot=Wslot, Lfeed=Lfeed, Wtaper=Wtaper, Ltaper=Ltapper, N=NumberOfPoints, Wtotal=subX, Ltotal=subY, Wbalun=Wbalun, Lbalun=Lbalun, Wstrip=Wstrip, Lstrip=Lstrip, Feed_offset=feed_offset, Lstrip_offset=Lstrip_offset, subH=subH)
  Port [copper] = part_of(VivaldiUDM1)
  PortCap [pec] = part_of(VivaldiUDM1)
  Stripline, Vivaldi [copper] = part_of(VivaldiUDM1)
  Substrate [Duroid (tm)] = box(corner=(0cm, -subX/2, 0cm), size=(subY, subX, subH))
  RadiatingSurface [vacuum] = region(absolute_offset=0.68965517cm on all sides)
boundaries and excitations:
  feedMetal: Perfect E Objects=Stripline
  antennaMetal: Perfect E Objects=Vivaldi
  AutoOpen1: Radiation Objects=RadiatingSurface
  Stripline_T1: Terminal port=1 Edges=Stripline.edge(at (0, -0.4336, 0.07875)) TerminalResistance=50ohm
  1: Wave Port Faces=Port.face(at (0, -0.9375, 0.07875)) WavePortType=Terminal NumModes=1
  reference conductors: PortCap
setups:
  ATK_Solution: HfssDriven MultipleAdaptiveFreqsSetup{AdaptAt{Frequency=8GHz Delta=0.02} AdaptAt{Frequency=21GHz Delta=0.02}} MaximumPasses=15 MinimumPasses=1 MinimumConvergedPasses=1 PercentRefinement=30 BasisOrder=1 PortAccuracy=2 DrivenSolverType="Direct Solver" IESolverType=ACA
    sweep SParam_Sweep: 8GHz to 21GHz step 0.065GHz; Type=Fast SaveFields
source amplitudes:
  1:1: 1V 0deg
radiation setups:
  3D: Infinite Sphere Theta=0deg..180deg step 2deg Phi=-180deg..180deg step 2deg
reports:
  S11: dB(St(Stripline_T1,Stripline_T1)) vs Freq on ATK_Solution : SParam_Sweep
  Gain: dB(GainTotal) vs Theta on ATK_Solution : LastAdaptive, 3D [Phi=0deg Freq=8GHz]

design 1 (HFSS, HFSS Hybrid Terminal Network, model units cm)
options: Allow_Material_Override Save_Adaptive_support_files open_region{BoundaryType=0 OpFreq=14.5GHz}
variables:
  # --Antenna Dimensions
  Wslot = 0.0395cm
  Lfeed = 0cm
  Wtaper = 1.868cm
  Ltapper = 3.957cm
  Wbalun = 0.307cm
  Lbalun = 0.35cm
  NumberOfPoints = 20
  # --Stripline Feed Dimensions
  Wstrip = 0.117cm
  Lstrip = 0.5cm
  Lstrip_offset = 0.335cm
  feed_offset = 0cm
  # --Substrate Dimensions
  subH = 0.1575cm
  subX = 3.75cm
  subY = 4.6cm
geometry:
  VivaldiUDM1 = component(Wslot=Wslot, Lfeed=Lfeed, Wtaper=Wtaper, Ltaper=Ltapper, N=NumberOfPoints, Wtotal=subX, Ltotal=subY, Wbalun=Wbalun, Lbalun=Lbalun, Wstrip=Wstrip, Lstrip=Lstrip, Feed_offset=feed_offset, Lstrip_offset=Lstrip_offset, subH=subH)
  Port [copper] = part_of(VivaldiUDM1)
  PortCap [pec] = part_of(VivaldiUDM1)
  Stripline, Vivaldi [copper] = part_of(VivaldiUDM1)
  Substrate [Duroid (tm)] = box(corner=(0cm, -subX/2, 0cm), size=(subY, subX, subH))
  RadiatingSurface [vacuum] = region(absolute_offset=0.68965517cm on all sides)
boundaries and excitations:
  feedMetal: Perfect E Objects=Stripline
  antennaMetal: Perfect E Objects=Vivaldi
  AutoOpen1: Radiation Objects=RadiatingSurface
  Stripline_T1: Terminal port=1 Edges=Stripline.edge(at (0, -0.4415, 0.07875)) TerminalResistance=50ohm
  1: Wave Port Faces=Port.face(at (0, -0.9375, 0.07875)) WavePortType=Terminal NumModes=1
  reference conductors: PortCap
setups:
  ATK_Solution: HfssDriven MultipleAdaptiveFreqsSetup{AdaptAt{Frequency=8GHz Delta=0.02} AdaptAt{Frequency=21GHz Delta=0.02}} MaximumPasses=15 MinimumPasses=1 MinimumConvergedPasses=1 PercentRefinement=30 BasisOrder=1 PortAccuracy=2 DrivenSolverType="Direct Solver" IESolverType=ACA
    sweep SParam_Sweep: 8GHz to 21GHz step 0.065GHz; Type=Fast SaveFields
source amplitudes:
  1:1: 1V 0deg
radiation setups:
  3D: Infinite Sphere Theta=0deg..180deg step 2deg Phi=-180deg..180deg step 2deg
reports:
  S11: dB(St(Stripline_T1,Stripline_T1)) vs Freq on ATK_Solution : SParam_Sweep
  Gain: dB(GainTotal) vs Theta on ATK_Solution : LastAdaptive, 3D [Phi=0deg Freq=8GHz]

design 2 (HFSS, HFSS Hybrid Terminal Network, model units cm)
options: Allow_Material_Override Save_Adaptive_support_files open_region{BoundaryType=0 OpFreq=14.5GHz}
variables:
  # --Antenna Dimensions
  Wslot = 0.0387cm
  Lfeed = 0cm
  Wtaper = 1.824cm
  Ltapper = 4.113cm
  Wbalun = 0.345cm
  Lbalun = 0.35cm
  NumberOfPoints = 20
  # --Stripline Feed Dimensions
  Wstrip = 0.122cm
  Lstrip = 0.5cm
  Lstrip_offset = 0.337cm
  feed_offset = 0cm
  # --Substrate Dimensions
  subH = 0.1575cm
  subX = 3.75cm
  subY = 4.6cm
geometry:
  VivaldiUDM1 = component(Wslot=Wslot, Lfeed=Lfeed, Wtaper=Wtaper, Ltaper=Ltapper, N=NumberOfPoints, Wtotal=subX, Ltotal=subY, Wbalun=Wbalun, Lbalun=Lbalun, Wstrip=Wstrip, Lstrip=Lstrip, Feed_offset=feed_offset, Lstrip_offset=Lstrip_offset, subH=subH)
  Port [copper] = part_of(VivaldiUDM1)
  PortCap [pec] = part_of(VivaldiUDM1)
  Stripline, Vivaldi [copper] = part_of(VivaldiUDM1)
  Substrate [Duroid (tm)] = box(corner=(0cm, -subX/2, 0cm), size=(subY, subX, subH))
  RadiatingSurface [vacuum] = region(absolute_offset=0.68965517cm on all sides)
boundaries and excitations:
  feedMetal: Perfect E Objects=Stripline
  antennaMetal: Perfect E Objects=Vivaldi
  AutoOpen1: Radiation Objects=RadiatingSurface
  Stripline_T1: Terminal port=1 Edges=Stripline.edge(at (0, -0.439, 0.07875)) TerminalResistance=50ohm
  1: Wave Port Faces=Port.face(at (0, -0.9375, 0.07875)) WavePortType=Terminal NumModes=1
  reference conductors: PortCap
setups:
  ATK_Solution: HfssDriven MultipleAdaptiveFreqsSetup{AdaptAt{Frequency=8GHz Delta=0.02} AdaptAt{Frequency=21GHz Delta=0.02}} MaximumPasses=15 MinimumPasses=1 MinimumConvergedPasses=1 PercentRefinement=30 BasisOrder=1 PortAccuracy=2 DrivenSolverType="Direct Solver" IESolverType=ACA
    sweep SParam_Sweep: 8GHz to 21GHz step 0.065GHz; Type=Fast SaveFields
source amplitudes:
  1:1: 1V 0deg
radiation setups:
  3D: Infinite Sphere Theta=0deg..180deg step 2deg Phi=-180deg..180deg step 2deg
reports:
  S11: dB(St(Stripline_T1,Stripline_T1)) vs Freq on ATK_Solution : SParam_Sweep
  Gain: dB(GainTotal) vs Theta on ATK_Solution : LastAdaptive, 3D [Phi=0deg Freq=8GHz]

design 3 (HFSS, HFSS Hybrid Terminal Network, model units cm)
options: Allow_Material_Override Save_Adaptive_support_files open_region{BoundaryType=0 OpFreq=14.5GHz}
variables:
  # --Antenna Dimensions
  Wslot = 0.0398cm
  Lfeed = 0cm
  Wtaper = 1.956cm
  Ltapper = 4.101cm
  Wbalun = 0.355cm
  Lbalun = 0.35cm
  NumberOfPoints = 20
  # --Stripline Feed Dimensions
  Wstrip = 0.149cm
  Lstrip = 0.5cm
  Lstrip_offset = 0.363cm
  feed_offset = 0cm
  # --Substrate Dimensions
  subH = 0.1575cm
  subX = 3.75cm
  subY = 4.6cm
geometry:
  VivaldiUDM1 = component(Wslot=Wslot, Lfeed=Lfeed, Wtaper=Wtaper, Ltaper=Ltapper, N=NumberOfPoints, Wtotal=subX, Ltotal=subY, Wbalun=Wbalun, Lbalun=Lbalun, Wstrip=Wstrip, Lstrip=Lstrip, Feed_offset=feed_offset, Lstrip_offset=Lstrip_offset, subH=subH)
  Port [copper] = part_of(VivaldiUDM1)
  PortCap [pec] = part_of(VivaldiUDM1)
  Stripline, Vivaldi [copper] = part_of(VivaldiUDM1)
  Substrate [Duroid (tm)] = box(corner=(0cm, -subX/2, 0cm), size=(subY, subX, subH))
  RadiatingSurface [vacuum] = region(absolute_offset=0.68965517cm on all sides)
boundaries and excitations:
  feedMetal: Perfect E Objects=Stripline
  antennaMetal: Perfect E Objects=Vivaldi
  AutoOpen1: Radiation Objects=RadiatingSurface
  Stripline_T1: Terminal port=1 Edges=Stripline.edge(at (0, -0.4255, 0.07875)) TerminalResistance=50ohm
  1: Wave Port Faces=Port.face(at (0, -0.9375, 0.07875)) WavePortType=Terminal NumModes=1
  reference conductors: PortCap
setups:
  ATK_Solution: HfssDriven MultipleAdaptiveFreqsSetup{AdaptAt{Frequency=8GHz Delta=0.02} AdaptAt{Frequency=21GHz Delta=0.02}} MaximumPasses=15 MinimumPasses=1 MinimumConvergedPasses=1 PercentRefinement=30 BasisOrder=1 PortAccuracy=2 DrivenSolverType="Direct Solver" IESolverType=ACA
    sweep SParam_Sweep: 8GHz to 21GHz step 0.065GHz; Type=Fast SaveFields
source amplitudes:
  1:1: 1V 0deg
radiation setups:
  3D: Infinite Sphere Theta=0deg..180deg step 2deg Phi=-180deg..180deg step 2deg
reports:
  S11: dB(St(Stripline_T1,Stripline_T1)) vs Freq on ATK_Solution : SParam_Sweep
  Gain: dB(GainTotal) vs Theta on ATK_Solution : LastAdaptive, 3D [Phi=0deg Freq=8GHz]

design 4 (HFSS, HFSS Hybrid Terminal Network, model units cm)
options: Allow_Material_Override Save_Adaptive_support_files open_region{BoundaryType=0 OpFreq=14.5GHz}
variables:
  # --Antenna Dimensions
  Wslot = 0.0397cm
  Lfeed = 0cm
  Wtaper = 1.964cm
  Ltapper = 4.011cm
  Wbalun = 0.334cm
  Lbalun = 0.35cm
  NumberOfPoints = 20
  # --Stripline Feed Dimensions
  Wstrip = 0.127cm
  Lstrip = 0.5cm
  Lstrip_offset = 0.3cm
  feed_offset = 0cm
  # --Substrate Dimensions
  subH = 0.1575cm
  subX = 3.75cm
  subY = 4.6cm
geometry:
  VivaldiUDM1 = component(Wslot=Wslot, Lfeed=Lfeed, Wtaper=Wtaper, Ltaper=Ltapper, N=NumberOfPoints, Wtotal=subX, Ltotal=subY, Wbalun=Wbalun, Lbalun=Lbalun, Wstrip=Wstrip, Lstrip=Lstrip, Feed_offset=feed_offset, Lstrip_offset=Lstrip_offset, subH=subH)
  Port [copper] = part_of(VivaldiUDM1)
  PortCap [pec] = part_of(VivaldiUDM1)
  Stripline, Vivaldi [copper] = part_of(VivaldiUDM1)
  Substrate [Duroid (tm)] = box(corner=(0cm, -subX/2, 0cm), size=(subY, subX, subH))
  RadiatingSurface [vacuum] = region(absolute_offset=0.68965517cm on all sides)
boundaries and excitations:
  feedMetal: Perfect E Objects=Stripline
  antennaMetal: Perfect E Objects=Vivaldi
  AutoOpen1: Radiation Objects=RadiatingSurface
  Stripline_T1: Terminal port=1 Edges=Stripline.edge(at (0, -0.4365, 0.07875)) TerminalResistance=50ohm
  1: Wave Port Faces=Port.face(at (0, -0.9375, 0.07875)) WavePortType=Terminal NumModes=1
  reference conductors: PortCap
setups:
  ATK_Solution: HfssDriven MultipleAdaptiveFreqsSetup{AdaptAt{Frequency=8GHz Delta=0.02} AdaptAt{Frequency=21GHz Delta=0.02}} MaximumPasses=15 MinimumPasses=1 MinimumConvergedPasses=1 PercentRefinement=30 BasisOrder=1 PortAccuracy=2 DrivenSolverType="Direct Solver" IESolverType=ACA
    sweep SParam_Sweep: 8GHz to 21GHz step 0.065GHz; Type=Fast SaveFields
source amplitudes:
  1:1: 1V 0deg
radiation setups:
  3D: Infinite Sphere Theta=0deg..180deg step 2deg Phi=-180deg..180deg step 2deg
reports:
  S11: dB(St(Stripline_T1,Stripline_T1)) vs Freq on ATK_Solution : SParam_Sweep
  Gain: dB(GainTotal) vs Theta on ATK_Solution : LastAdaptive, 3D [Phi=0deg Freq=8GHz]

design 6 (HFSS, HFSS Hybrid Terminal Network, model units cm)
options: Allow_Material_Override Save_Adaptive_support_files open_region{BoundaryType=0 OpFreq=14.5GHz}
variables:
  # --Antenna Dimensions
  Wslot = 0.0321cm
  Lfeed = 0cm
  Wtaper = 1.936cm
  Ltapper = 4.064cm
  Wbalun = 0.383cm
  Lbalun = 0.35cm
  NumberOfPoints = 20
  # --Stripline Feed Dimensions
  Wstrip = 0.141cm
  Lstrip = 0.5cm
  Lstrip_offset = 0.3768cm
  feed_offset = 0cm
  # --Substrate Dimensions
  subH = 0.1575cm
  subX = 3.75cm
  subY = 4.6cm
geometry:
  VivaldiUDM1 = component(Wslot=Wslot, Lfeed=Lfeed, Wtaper=Wtaper, Ltaper=Ltapper, N=NumberOfPoints, Wtotal=subX, Ltotal=subY, Wbalun=Wbalun, Lbalun=Lbalun, Wstrip=Wstrip, Lstrip=Lstrip, Feed_offset=feed_offset, Lstrip_offset=Lstrip_offset, subH=subH)
  Port [copper] = part_of(VivaldiUDM1)
  PortCap [pec] = part_of(VivaldiUDM1)
  Stripline, Vivaldi [copper] = part_of(VivaldiUDM1)
  Substrate [Duroid (tm)] = box(corner=(0cm, -subX/2, 0cm), size=(subY, subX, subH))
  RadiatingSurface [vacuum] = region(absolute_offset=0.68965517cm on all sides)
boundaries and excitations:
  feedMetal: Perfect E Objects=Stripline
  antennaMetal: Perfect E Objects=Vivaldi
  AutoOpen1: Radiation Objects=RadiatingSurface
  Stripline_T1: Terminal port=1 Edges=Stripline.edge(at (0, -0.4295, 0.07875)) TerminalResistance=50ohm
  1: Wave Port Faces=Port.face(at (0, -0.9375, 0.07875)) WavePortType=Terminal NumModes=1
  reference conductors: PortCap
setups:
  ATK_Solution: HfssDriven MultipleAdaptiveFreqsSetup{AdaptAt{Frequency=8GHz Delta=0.02} AdaptAt{Frequency=21GHz Delta=0.02}} MaximumPasses=15 MinimumPasses=1 MinimumConvergedPasses=1 PercentRefinement=30 BasisOrder=1 PortAccuracy=2 DrivenSolverType="Direct Solver" IESolverType=ACA
    sweep SParam_Sweep: 8GHz to 21GHz step 0.065GHz; Type=Fast SaveFields
source amplitudes:
  1:1: 1V 0deg
radiation setups:
  3D: Infinite Sphere Theta=0deg..180deg step 2deg Phi=-180deg..180deg step 2deg
reports:
  S11: dB(St(Stripline_T1,Stripline_T1)) vs Freq on ATK_Solution : SParam_Sweep
  Gain: dB(GainTotal) vs Theta on ATK_Solution : LastAdaptive, 3D [Phi=0deg Freq=8GHz]

design 5 (HFSS, HFSS Hybrid Terminal Network, model units cm)
options: Allow_Material_Override Save_Adaptive_support_files open_region{BoundaryType=0 OpFreq=14.5GHz}
variables:
  # --Antenna Dimensions
  Wslot = 0.0248cm
  Lfeed = 0cm
  Wtaper = 1.979cm
  Ltapper = 3.986cm
  Wbalun = 0.373cm
  Lbalun = 0.35cm
  NumberOfPoints = 20
  # --Stripline Feed Dimensions
  Wstrip = 0.122cm
  Lstrip = 0.5cm
  Lstrip_offset = 0.376cm
  feed_offset = 0cm
  # --Substrate Dimensions
  subH = 0.1575cm
  subX = 3.75cm
  subY = 4.6cm
geometry:
  VivaldiUDM1 = component(Wslot=Wslot, Lfeed=Lfeed, Wtaper=Wtaper, Ltaper=Ltapper, N=NumberOfPoints, Wtotal=subX, Ltotal=subY, Wbalun=Wbalun, Lbalun=Lbalun, Wstrip=Wstrip, Lstrip=Lstrip, Feed_offset=feed_offset, Lstrip_offset=Lstrip_offset, subH=subH)
  Port [copper] = part_of(VivaldiUDM1)
  PortCap [pec] = part_of(VivaldiUDM1)
  Stripline, Vivaldi [copper] = part_of(VivaldiUDM1)
  Substrate [Duroid (tm)] = box(corner=(0cm, -subX/2, 0cm), size=(subY, subX, subH))
  RadiatingSurface [vacuum] = region(absolute_offset=0.68965517cm on all sides)
boundaries and excitations:
  feedMetal: Perfect E Objects=Stripline
  antennaMetal: Perfect E Objects=Vivaldi
  AutoOpen1: Radiation Objects=RadiatingSurface
  Stripline_T1: Terminal port=1 Edges=Stripline.edge(at (0, -0.439, 0.07875)) TerminalResistance=50ohm
  1: Wave Port Faces=Port.face(at (0, -0.9375, 0.07875)) WavePortType=Terminal NumModes=1
  reference conductors: PortCap
setups:
  ATK_Solution: HfssDriven MultipleAdaptiveFreqsSetup{AdaptAt{Frequency=8GHz Delta=0.02} AdaptAt{Frequency=21GHz Delta=0.02}} MaximumPasses=15 MinimumPasses=1 MinimumConvergedPasses=1 PercentRefinement=30 BasisOrder=1 PortAccuracy=2 DrivenSolverType="Direct Solver" IESolverType=ACA
    sweep SParam_Sweep: 8GHz to 21GHz step 0.065GHz; Type=Fast SaveFields
source amplitudes:
  1:1: 1V 0deg
radiation setups:
  3D: Infinite Sphere Theta=0deg..180deg step 2deg Phi=-180deg..180deg step 2deg
reports:
  S11: dB(St(Stripline_T1,Stripline_T1)) vs Freq on ATK_Solution : SParam_Sweep
  Gain: dB(GainTotal) vs Theta on ATK_Solution : LastAdaptive, 3D [Phi=0deg Freq=8GHz]
