# Ansys Electronics Desktop project, version 2024.2
materials:
  vacuum: permittivity=1
  Rogers: permittivity=10.2

design Quasi_Yagi_ATK (HFSS, HFSS Hybrid Terminal Network, model units mm)
options: Allow_Material_Override Save_Adaptive_support_files open_region{BoundaryType=0 OpFreq=2.25GHz}
variables:
  # --Width Dimensions
  Wdir = 3mm
  Wdri = 3mm
  W1 = 3mm
  W2 = 6mm
  W3 = 3mm
  W4 = 3mm
  W5 = 3mm
  W6 = 1.5mm
  # --Length Dimensions
  Ldir = 16.5mm
  Ldri = 43.5mm
  L1 = 16.5mm
  L2 = 7.5mm
  L3 = 24mm
  L4 = 9mm
  L5 = 7.5mm
  # --Spacing Dimensions
  Sdir = 15mm
  Sref = 19.5mm
  Ssub = 7.5mm
  S5 = 1.5mm
  S6 = 1.5mm
  # --Substrate Dimensions
  Substrate_Th = 3.175mm
  Substrate_Width = 75mm
geometry:
  Substrate [Rogers] = box(corner=(0mm, -Substrate_Width/2, 0mm), size=(-Substrate_Th, Substrate_Width, -(Ssub+Sdir+Sref+L5+L4+L1+2*W1)))
  Ground = rectangle(corner=(-Substrate_Th, -Substrate_Width/2, -(L5+L4+L1+2*W1)-Ssub-Sdir-Sref), y_size=Substrate_Width, z_size=(L5+L4+L1+2*W1))
  Director = rectangle(corner=(0mm, -Ldir/2, (-Wdir/2)-Ssub), y_size=Ldir, z_size=Wdir)
  Driver = rectangle(corner=(0mm, -Ldri/2, (-Wdri/2)-Ssub-Sdir), y_size=Ldri, z_size=Wdri)
  NewObject_C8R3FB = rectangle(corner=(0mm, -S6/2, (-Wdri/2)-Ssub-Sdir), y_size=S6, z_size=Wdri)
  NewObject_RK7LWU = rectangle(corner=(0mm, -(2*W6+S6)/2, -Ssub-Sdir-Sref), y_size=(2*W6+S6), z_size=Sref)
  NewObject_JVRP9U = rectangle(corner=(0mm, -S6/2, -Ssub-Sdir-Sref), y_size=S6, z_size=Sref)
  NewObject_L54683 = rectangle(corner=(0mm, -(2*W5+S5)/2, (W3/2)-sSub-Sdir-Sref-L5), y_size=(2*W5+S5), z_size=L5-(W3/2))
  NewObject_1MLUWC = rectangle(corner=(0mm, -S5/2, -sSub-Sdir-Sref-L5), y_size=S5, z_size=L5)
  NewObject_WEMH53 = rectangle(corner=(0mm, -S5/2, (-W3/2)-sSub-Sdir-Sref-L5), y_size=S5, z_size=W3)
  NewObject_IPT40X = rectangle(corner=(0mm, -(L2+W4/2), (-W3/2)-Ssub-Sdir-Sref-L5), y_size=L2+L3+2*W4, z_size=W3)
  NewObject_9MHQV8 = rectangle(corner=(0mm, -(S5/2), (-W3/2)-Ssub-Sdir-Sref-L5-L4), y_size=S5, z_size=W3)
  NewObject_9HP0Z3 = rectangle(corner=(0mm, -(L2+W4/2), (-W3/2)-Ssub-Sdir-Sref-L5-L4), y_size=L2+L3+2*W4, z_size=W3)
  NewObject_QDASEZ = rectangle(corner=(0mm, -(L2+W4/2), (-W3/2)-Ssub-Sdir-Sref-L5-L4), y_size=W4, z_size=L2+1.5*W3)
  NewObject_04U3XR = rectangle(corner=(0mm, (L3+W4/2), (-W3/2)-Ssub-Sdir-Sref-L5-L4), y_size=W4, z_size=L2+1.5*W3)
  NewObject_IPT40X.unite(NewObject_9HP0Z3, NewObject_QDASEZ, NewObject_04U3XR)
  NewObject_IPT40X.subtract(NewObject_WEMH53, NewObject_9MHQV8)
  NewObject_IPT40X1 = rectangle(corner=(0mm, -(L2+W4/2), (-W3/2)-Ssub-Sdir-Sref-L5), y_size=L2+L3+2*W4, z_size=W3)
  NewObject_9HP0Z4 = rectangle(corner=(0mm, -(L2+W4/2), (-W3/2)-Ssub-Sdir-Sref-L5-L4), y_size=L2+L3+2*W4, z_size=W3)
  NewObject_QDASEZ1 = rectangle(corner=(0mm, -(L2+W4/2), (-W3/2)-Ssub-Sdir-Sref-L5-L4), y_size=W4, z_size=L2+1.5*W3)
  NewObject_04U3XR1 = rectangle(corner=(0mm, (L3+W4/2), (-W3/2)-Ssub-Sdir-Sref-L5-L4), y_size=W4, z_size=L2+1.5*W3)
  NewObject_IPT40X1.unite(NewObject_9HP0Z4, NewObject_QDASEZ1, NewObject_04U3XR1)
  NewObject_WEMH54 = rectangle(corner=(0mm, -S5/2, (-W3/2)-sSub-Sdir-Sref-L5), y_size=S5, z_size=W3)
  NewObject_9MHQV9 = rectangle(corner=(0mm, -(S5/2), (-W3/2)-Ssub-Sdir-Sref-L5-L4), y_size=S5, z_size=W3)
  NewObject_IPT40X1.subtract(NewObject_WEMH54, NewObject_9MHQV9)
  NewObject_IPT40X.thicken(1mm)
  NewObject_IPT40X.chamfer(Edges=NewObject_IPT40X.edge(at (0.5, -9, -60), at (0.5, -9, -48), at (0.5, 28.5, -60), at (0.5, 28.5, -48)) LeftDistance=W4 RightDistance=W4 ChamferType=Symmetric ChamferAdditionalGeometryInfo{ChamferEdgeGeometryInfo{ChamferEdgeID=354 ChamferEdgeSense ChamferEdgeStart{X=4.8243679e-16mm Y=-9mm Z=-48mm} ChamferEdgeEnd{X=1mm Y=-9mm Z=-48mm} ChamferEdgeMid{X=0.5mm Y=-9mm Z=-48mm} ChamferEdgeMidTangent(1, -6.123234e-17, -1.6081226e-16)} ChamferEdgeGeometryInfo{ChamferEdgeID=355 ChamferEdgeSense ChamferEdgeStart{X=0mm Y=-9mm Z=-60mm} ChamferEdgeEnd{X=1mm Y=-9mm Z=-60mm} ChamferEdgeMid{X=0.5mm Y=-9mm Z=-60mm} ChamferEdgeMidTangent(1, -6.123234e-17, -1.6081226e-16)} ChamferEdgeGeometryInfo{ChamferEdgeID=358 ChamferEdgeSense ChamferEdgeStart{X=2.2962127e-15mm Y=28.5mm Z=-60mm} ChamferEdgeEnd{X=1mm Y=28.5mm Z=-60mm} ChamferEdgeMid{X=0.5mm Y=28.5mm Z=-60mm} ChamferEdgeMidTangent(1, -6.123234e-17, -1.6081226e-16)} ChamferEdgeGeometryInfo{ChamferEdgeID=359 ChamferEdgeSense ChamferEdgeStart{X=2.7786495e-15mm Y=28.5mm Z=-48mm} ChamferEdgeEnd{X=1mm Y=28.5mm Z=-48mm} ChamferEdgeMid{X=0.5mm Y=28.5mm Z=-48mm} ChamferEdgeMidTangent(1, -6.123234e-17, -1.6081226e-16)}})
  NewObject_IPT40X.chamfer(Edges=NewObject_IPT40X.edge(at (0.5, -0.75, -51), at (0.5, 0.75, -51), at (0.5, -0.75, -57), at (0.5, 0.75, -57)) LeftDistance=W3 RightDistance=W3 ChamferType=Symmetric ChamferAdditionalGeometryInfo{ChamferEdgeGeometryInfo{ChamferEdgeID=352 ChamferEdgeSense ChamferEdgeStart{X=5.051668e-16mm Y=-0.75mm Z=-51mm} ChamferEdgeEnd{X=1mm Y=-0.75mm Z=-51mm} ChamferEdgeMid{X=0.5mm Y=-0.75mm Z=-51mm} ChamferEdgeMidTangent(1, -6.123234e-17, -1.6081226e-16)} ChamferEdgeGeometryInfo{ChamferEdgeID=357 ChamferEdgeSense ChamferEdgeStart{X=9.876036e-16mm Y=-0.75mm Z=-57mm} ChamferEdgeEnd{X=1mm Y=-0.75mm Z=-57mm} ChamferEdgeMid{X=0.5mm Y=-0.75mm Z=-57mm} ChamferEdgeMidTangent(1, -6.123234e-17, -1.6081226e-16)} ChamferEdgeGeometryInfo{ChamferEdgeID=361 ChamferEdgeSense ChamferEdgeStart{X=5.9701531e-16mm Y=0.75mm Z=-51mm} ChamferEdgeEnd{X=1mm Y=0.75mm Z=-51mm} ChamferEdgeMid{X=0.5mm Y=0.75mm Z=-51mm} ChamferEdgeMidTangent(1, -6.123234e-17, -1.6081226e-16)} ChamferEdgeGeometryInfo{ChamferEdgeID=364 ChamferEdgeSense ChamferEdgeStart{X=1.0794521e-15mm Y=0.75mm Z=-57mm} ChamferEdgeEnd{X=1mm Y=0.75mm Z=-57mm} ChamferEdgeMid{X=0.5mm Y=0.75mm Z=-57mm} ChamferEdgeMidTangent(1, -6.123234e-17, -1.6081226e-16)}})
  NewObject_IPT40X1.intersect(NewObject_IPT40X)
  NewObject_CN9EAS = rectangle(corner=(0mm, -W2/2, -Ssub-Sdir-Sref-L5-L4-L1), y_size=W2, z_size=L1-(W3/2))
  NewObject_ZJX4TP = rectangle(corner=(0mm, -W1/2, -W1-Ssub-Sdir-Sref-L5-L4-L1), y_size=W1, z_size=W1)
  Driver.unite(NewObject_RK7LWU, NewObject_L54683, NewObject_CN9EAS, NewObject_ZJX4TP, NewObject_IPT40X1)
  Driver.subtract(NewObject_C8R3FB, NewObject_JVRP9U, NewObject_1MLUWC)
  port1 = rectangle(corner=(0mm, -W1/2, -W1-Ssub-Sdir-Sref-L5-L4-L1), x_size=-Substrate_Th, y_size=W1)
  RadiatingSurface [vacuum] = region(absolute_offset=44.444444mm on all sides)
boundaries and excitations:
  antennaMetal: Perfect E Objects=[Director, Driver]
  groundMetal: Perfect E Objects=Ground
  AutoOpen1: Radiation Objects=RadiatingSurface
  Driver_T1: Terminal port=1 Edges=Driver.edge(at (0, 0, -78)) TerminalResistance=50ohm
  1: Lumped Port Faces=port1.face LumpedPortType=Terminal Impedance=50ohm
  reference conductors: Ground
setups:
  ATK_Solution: HfssDriven Frequency=2.25GHz MaxDeltaS=0.02 MaximumPasses=15 MinimumPasses=1 MinimumConvergedPasses=1 PercentRefinement=30 BasisOrder=1 PortAccuracy=2 DrivenSolverType="Direct Solver" IESolverType=ACA
    sweep FF_Sweep: 1GHz to 3GHz step 0.005GHz; Type=Fast SaveFields
source amplitudes:
  1:1: 1V 0deg
radiation setups:
  3D: Infinite Sphere Theta=0deg..180deg step 2deg Phi=-180deg..180deg step 2deg
reports:
  S11: dB(St(Driver_T1,Driver_T1)) vs Freq on ATK_Solution : FF_Sweep
  Gain Plot 4: dB(GainTotal) vs Theta on ATK_Solution : FF_Sweep, 3D [Phi=90deg Freq=2.25GHz]
  Gain Plot 5: dB(GainTotal) vs Theta on ATK_Solution : FF_Sweep, 3D [Phi=0deg Freq=2.25GHz]
  ATK_OBJ_S11_F0: dB(St(Driver_T1,Driver_T1)) vs Freq on ATK_Solution : FF_Sweep [Freq=2.25GHz]
  ATK_OBJ_Cut_Phi0: dB(GainTotal) vs Theta on ATK_Solution : FF_Sweep, 3D [Phi=0deg Freq=2.25GHz]
  ATK_OBJ_Cut_Phi90: dB(GainTotal) vs Theta on ATK_Solution : FF_Sweep, 3D [Phi=90deg Freq=2.25GHz]
  ATK_OBJ_PeakGain: dB(PeakGain), dB(PeakRealizedGain), FrontToBackRatio vs Freq on ATK_Solution : FF_Sweep [Freq=2.25GHz]

design 1 (HFSS, HFSS Hybrid Terminal Network, model units mm)
options: Allow_Material_Override Save_Adaptive_support_files open_region{BoundaryType=0 OpFreq=2.25GHz}
variables:
  # --Width Dimensions
  Wdir = 3mm
  Wdri = 4.234mm
  W1 = 3mm
  W2 = 6mm
  W3 = 3mm
  W4 = 3mm
  W5 = 3mm
  W6 = 1.5mm
  # --Length Dimensions
  Ldir = 17.897mm
  Ldri = 45.487mm
  L1 = 18.217mm
  L2 = 7.5mm
  L3 = 24mm
  L4 = 9mm
  L5 = 7.5mm
  # --Spacing Dimensions
  Sdir = 17.376mm
  Sref = 20.929mm
  Ssub = 7.5mm
  S5 = 1.5mm
  S6 = 1.5mm
  # --Substrate Dimensions
  Substrate_Th = 3.175mm
  Substrate_Width = 75mm
geometry:
  Substrate [Rogers] = box(corner=(0mm, -Substrate_Width/2, 0mm), size=(-Substrate_Th, Substrate_Width, -(Ssub+Sdir+Sref+L5+L4+L1+2*W1)))
  Ground = rectangle(corner=(-Substrate_Th, -Substrate_Width/2, -(L5+L4+L1+2*W1)-Ssub-Sdir-Sref), y_size=Substrate_Width, z_size=(L5+L4+L1+2*W1))
  Director = rectangle(corner=(0mm, -Ldir/2, (-Wdir/2)-Ssub), y_size=Ldir, z_size=Wdir)
  Driver = rectangle(corner=(0mm, -Ldri/2, (-Wdri/2)-Ssub-Sdir), y_size=Ldri, z_size=Wdri)
  NewObject_C8R3FB = rectangle(corner=(0mm, -S6/2, (-Wdri/2)-Ssub-Sdir), y_size=S6, z_size=Wdri)
  NewObject_RK7LWU = rectangle(corner=(0mm, -(2*W6+S6)/2, -Ssub-Sdir-Sref), y_size=(2*W6+S6), z_size=Sref)
  NewObject_JVRP9U = rectangle(corner=(0mm, -S6/2, -Ssub-Sdir-Sref), y_size=S6, z_size=Sref)
  NewObject_L54683 = rectangle(corner=(0mm, -(2*W5+S5)/2, (W3/2)-sSub-Sdir-Sref-L5), y_size=(2*W5+S5), z_size=L5-(W3/2))
  NewObject_1MLUWC = rectangle(corner=(0mm, -S5/2, -sSub-Sdir-Sref-L5), y_size=S5, z_size=L5)
  NewObject_WEMH53 = rectangle(corner=(0mm, -S5/2, (-W3/2)-sSub-Sdir-Sref-L5), y_size=S5, z_size=W3)
  NewObject_IPT40X = rectangle(corner=(0mm, -(L2+W4/2), (-W3/2)-Ssub-Sdir-Sref-L5), y_size=L2+L3+2*W4, z_size=W3)
  NewObject_9MHQV8 = rectangle(corner=(0mm, -(S5/2), (-W3/2)-Ssub-Sdir-Sref-L5-L4), y_size=S5, z_size=W3)
  NewObject_9HP0Z3 = rectangle(corner=(0mm, -(L2+W4/2), (-W3/2)-Ssub-Sdir-Sref-L5-L4), y_size=L2+L3+2*W4, z_size=W3)
  NewObject_QDASEZ = rectangle(corner=(0mm, -(L2+W4/2), (-W3/2)-Ssub-Sdir-Sref-L5-L4), y_size=W4, z_size=L2+1.5*W3)
  NewObject_04U3XR = rectangle(corner=(0mm, (L3+W4/2), (-W3/2)-Ssub-Sdir-Sref-L5-L4), y_size=W4, z_size=L2+1.5*W3)
  NewObject_IPT40X.unite(NewObject_9HP0Z3, NewObject_QDASEZ, NewObject_04U3XR)
  NewObject_IPT40X.subtract(NewObject_WEMH53, NewObject_9MHQV8)
  NewObject_IPT40X1 = rectangle(corner=(0mm, -(L2+W4/2), (-W3/2)-Ssub-Sdir-Sref-L5), y_size=L2+L3+2*W4, z_size=W3)
  NewObject_9HP0Z4 = rectangle(corner=(0mm, -(L2+W4/2), (-W3/2)-Ssub-Sdir-Sref-L5-L4), y_size=L2+L3+2*W4, z_size=W3)
  NewObject_QDASEZ1 = rectangle(corner=(0mm, -(L2+W4/2), (-W3/2)-Ssub-Sdir-Sref-L5-L4), y_size=W4, z_size=L2+1.5*W3)
  NewObject_04U3XR1 = rectangle(corner=(0mm, (L3+W4/2), (-W3/2)-Ssub-Sdir-Sref-L5-L4), y_size=W4, z_size=L2+1.5*W3)
  NewObject_IPT40X1.unite(NewObject_9HP0Z4, NewObject_QDASEZ1, NewObject_04U3XR1)
  NewObject_WEMH54 = rectangle(corner=(0mm, -S5/2, (-W3/2)-sSub-Sdir-Sref-L5), y_size=S5, z_size=W3)
  NewObject_9MHQV9 = rectangle(corner=(0mm, -(S5/2), (-W3/2)-Ssub-Sdir-Sref-L5-L4), y_size=S5, z_size=W3)
  NewObject_IPT40X1.subtract(NewObject_WEMH54, NewObject_9MHQV9)
  NewObject_IPT40X.thicken(1mm)
  NewObject_IPT40X.chamfer(Edges=NewObject_IPT40X.edge(at (0.5, -9, -63.805), at (0.5, -9, -51.805), at (0.5, 28.5, -63.805), at (0.5, 28.5, -51.805)) LeftDistance=W4 RightDistance=W4 ChamferType=Symmetric ChamferAdditionalGeometryInfo{ChamferEdgeGeometryInfo{ChamferEdgeID=354 ChamferEdgeSense ChamferEdgeStart{X=4.8243679e-16mm Y=-9mm Z=-51.805mm} ChamferEdgeEnd{X=1mm Y=-9mm Z=-51.805mm} ChamferEdgeMid{X=0.5mm Y=-9mm Z=-51.805mm} ChamferEdgeMidTangent(1, -6.123234e-17, -1.6081226e-16)} ChamferEdgeGeometryInfo{ChamferEdgeID=355 ChamferEdgeSense ChamferEdgeStart{X=0mm Y=-9mm Z=-63.805mm} ChamferEdgeEnd{X=1mm Y=-9mm Z=-63.805mm} ChamferEdgeMid{X=0.5mm Y=-9mm Z=-63.805mm} ChamferEdgeMidTangent(1, -6.123234e-17, -1.6081226e-16)} ChamferEdgeGeometryInfo{ChamferEdgeID=358 ChamferEdgeSense ChamferEdgeStart{X=2.2962127e-15mm Y=28.5mm Z=-63.805mm} ChamferEdgeEnd{X=1mm Y=28.5mm Z=-63.805mm} ChamferEdgeMid{X=0.5mm Y=28.5mm Z=-63.805mm} ChamferEdgeMidTangent(1, -6.123234e-17, -1.6081226e-16)} ChamferEdgeGeometryInfo{ChamferEdgeID=359 ChamferEdgeSense ChamferEdgeStart{X=2.7786495e-15mm Y=28.5mm Z=-51.805mm} ChamferEdgeEnd{X=1mm Y=28.5mm Z=-51.805mm} ChamferEdgeMid{X=0.5mm Y=28.5mm Z=-51.805mm} ChamferEdgeMidTangent(1, -6.123234e-17, -1.6081226e-16)}})
  NewObject_IPT40X.chamfer(Edges=NewObject_IPT40X.edge(at (0.5, -0.75, -54.805), at (0.5, 0.75, -54.805), at (0.5, -0.75, -60.805), at (0.5, 0.75, -60.805)) LeftDistance=W3 RightDistance=W3 ChamferType=Symmetric ChamferAdditionalGeometryInfo{ChamferEdgeGeometryInfo{ChamferEdgeID=352 ChamferEdgeSense ChamferEdgeStart{X=5.051668e-16mm Y=-0.75mm Z=-54.805mm} ChamferEdgeEnd{X=1mm Y=-0.75mm Z=-54.805mm} ChamferEdgeMid{X=0.5mm Y=-0.75mm Z=-54.805mm} ChamferEdgeMidTangent(1, -6.123234e-17, -1.6081226e-16)} ChamferEdgeGeometryInfo{ChamferEdgeID=357 ChamferEdgeSense ChamferEdgeStart{X=9.876036e-16mm Y=-0.75mm Z=-60.805mm} ChamferEdgeEnd{X=1mm Y=-0.75mm Z=-60.805mm} ChamferEdgeMid{X=0.5mm Y=-0.75mm Z=-60.805mm} ChamferEdgeMidTangent(1, -6.123234e-17, -1.6081226e-16)} ChamferEdgeGeometryInfo{ChamferEdgeID=361 ChamferEdgeSense ChamferEdgeStart{X=5.9701531e-16mm Y=0.75mm Z=-54.805mm} ChamferEdgeEnd{X=1mm Y=0.75mm Z=-54.805mm} ChamferEdgeMid{X=0.5mm Y=0.75mm Z=-54.805mm} ChamferEdgeMidTangent(1, -6.123234e-17, -1.6081226e-16)} ChamferEdgeGeometryInfo{ChamferEdgeID=364 ChamferEdgeSense ChamferEdgeStart{X=1.0794521e-15mm Y=0.75mm Z=-60.805mm} ChamferEdgeEnd{X=1mm Y=0.75mm Z=-60.805mm} ChamferEdgeMid{X=0.5mm Y=0.75mm Z=-60.805mm} ChamferEdgeMidTangent(1, -6.123234e-17, -1.6081226e-16)}})
  NewObject_IPT40X1.intersect(NewObject_IPT40X)
  NewObject_CN9EAS = rectangle(corner=(0mm, -W2/2, -Ssub-Sdir-Sref-L5-L4-L1), y_size=W2, z_size=L1-(W3/2))
  NewObject_ZJX4TP = rectangle(corner=(0mm, -W1/2, -W1-Ssub-Sdir-Sref-L5-L4-L1), y_size=W1, z_size=W1)
  Driver.unite(NewObject_RK7LWU, NewObject_L54683, NewObject_CN9EAS, NewObject_ZJX4TP, NewObject_IPT40X1)
  Driver.subtract(NewObject_C8R3FB, NewObject_JVRP9U, NewObject_1MLUWC)
  port1 = rectangle(corner=(0mm, -W1/2, -W1-Ssub-Sdir-Sref-L5-L4-L1), x_size=-Substrate_Th, y_size=W1)
  RadiatingSurface [vacuum] = region(absolute_offset=44.444444mm on all sides)
boundaries and excitations:
  antennaMetal: Perfect E Objects=[Director, Driver]
  groundMetal: Perfect E Objects=Ground
  AutoOpen1: Radiation Objects=RadiatingSurface
  Driver_T1: Terminal port=1 Edges=Driver.edge(at (0, 0, -83.522)) TerminalResistance=50ohm
  1: Lumped Port Faces=port1.face LumpedPortType=Terminal Impedance=50ohm
  reference conductors: Ground
setups:
  ATK_Solution: HfssDriven Frequency=2.25GHz MaxDeltaS=0.02 MaximumPasses=15 MinimumPasses=1 MinimumConvergedPasses=1 PercentRefinement=30 BasisOrder=1 PortAccuracy=2 DrivenSolverType="Direct Solver" IESolverType=ACA
    sweep FF_Sweep: 1GHz to 3GHz step 0.005GHz; Type=Fast SaveFields
source amplitudes:
  1:1: 1V 0deg
radiation setups:
  3D: Infinite Sphere Theta=0deg..180deg step 2deg Phi=-180deg..180deg step 2deg
reports:
  S11: dB(St(Driver_T1,Driver_T1)) vs Freq on ATK_Solution : FF_Sweep
  Gain Plot 4: dB(GainTotal) vs Theta on ATK_Solution : FF_Sweep, 3D [Phi=90deg Freq=2.25GHz]
  Gain Plot 5: dB(GainTotal) vs Theta on ATK_Solution : FF_Sweep, 3D [Phi=0deg Freq=2.25GHz]
  ATK_OBJ_S11_F0: dB(St(Driver_T1,Driver_T1)) vs Freq on ATK_Solution : FF_Sweep [Freq=2.25GHz]
  ATK_OBJ_Cut_Phi0: dB(GainTotal) vs Theta on ATK_Solution : FF_Sweep, 3D [Phi=0deg Freq=2.25GHz]
  ATK_OBJ_Cut_Phi90: dB(GainTotal) vs Theta on ATK_Solution : FF_Sweep, 3D [Phi=90deg Freq=2.25GHz]
  ATK_OBJ_PeakGain: dB(PeakGain), dB(PeakRealizedGain), FrontToBackRatio vs Freq on ATK_Solution : FF_Sweep [Freq=2.25GHz]

design 2 (HFSS, HFSS Hybrid Terminal Network, model units mm)
options: Allow_Material_Override Save_Adaptive_support_files open_region{BoundaryType=0 OpFreq=2.25GHz}
variables:
  # --Width Dimensions
  Wdir = 3mm
  Wdri = 2.349mm
  W1 = 3mm
  W2 = 6mm
  W3 = 3mm
  W4 = 3mm
  W5 = 3mm
  W6 = 1.5mm
  # --Length Dimensions
  Ldir = 15.129mm
  Ldri = 46.794mm
  L1 = 14.624mm
  L2 = 7.5mm
  L3 = 24mm
  L4 = 9mm
  L5 = 7.5mm
  # --Spacing Dimensions
  Sdir = 15.493mm
  Sref = 19.428mm
  Ssub = 7.5mm
  S5 = 1.5mm
  S6 = 1.5mm
  # --Substrate Dimensions
  Substrate_Th = 3.175mm
  Substrate_Width = 75mm
geometry:
  Substrate [Rogers] = box(corner=(0mm, -Substrate_Width/2, 0mm), size=(-Substrate_Th, Substrate_Width, -(Ssub+Sdir+Sref+L5+L4+L1+2*W1)))
  Ground = rectangle(corner=(-Substrate_Th, -Substrate_Width/2, -(L5+L4+L1+2*W1)-Ssub-Sdir-Sref), y_size=Substrate_Width, z_size=(L5+L4+L1+2*W1))
  Director = rectangle(corner=(0mm, -Ldir/2, (-Wdir/2)-Ssub), y_size=Ldir, z_size=Wdir)
  Driver = rectangle(corner=(0mm, -Ldri/2, (-Wdri/2)-Ssub-Sdir), y_size=Ldri, z_size=Wdri)
  NewObject_C8R3FB = rectangle(corner=(0mm, -S6/2, (-Wdri/2)-Ssub-Sdir), y_size=S6, z_size=Wdri)
  NewObject_RK7LWU = rectangle(corner=(0mm, -(2*W6+S6)/2, -Ssub-Sdir-Sref), y_size=(2*W6+S6), z_size=Sref)
  NewObject_JVRP9U = rectangle(corner=(0mm, -S6/2, -Ssub-Sdir-Sref), y_size=S6, z_size=Sref)
  NewObject_L54683 = rectangle(corner=(0mm, -(2*W5+S5)/2, (W3/2)-sSub-Sdir-Sref-L5), y_size=(2*W5+S5), z_size=L5-(W3/2))
  NewObject_1MLUWC = rectangle(corner=(0mm, -S5/2, -sSub-Sdir-Sref-L5), y_size=S5, z_size=L5)
  NewObject_WEMH53 = rectangle(corner=(0mm, -S5/2, (-W3/2)-sSub-Sdir-Sref-L5), y_size=S5, z_size=W3)
  NewObject_IPT40X = rectangle(corner=(0mm, -(L2+W4/2), (-W3/2)-Ssub-Sdir-Sref-L5), y_size=L2+L3+2*W4, z_size=W3)
  NewObject_9MHQV8 = rectangle(corner=(0mm, -(S5/2), (-W3/2)-Ssub-Sdir-Sref-L5-L4), y_size=S5, z_size=W3)
  NewObject_9HP0Z3 = rectangle(corner=(0mm, -(L2+W4/2), (-W3/2)-Ssub-Sdir-Sref-L5-L4), y_size=L2+L3+2*W4, z_size=W3)
  NewObject_QDASEZ = rectangle(corner=(0mm, -(L2+W4/2), (-W3/2)-Ssub-Sdir-Sref-L5-L4), y_size=W4, z_size=L2+1.5*W3)
  NewObject_04U3XR = rectangle(corner=(0mm, (L3+W4/2), (-W3/2)-Ssub-Sdir-Sref-L5-L4), y_size=W4, z_size=L2+1.5*W3)
  NewObject_IPT40X.unite(NewObject_9HP0Z3, NewObject_QDASEZ, NewObject_04U3XR)
  NewObject_IPT40X.subtract(NewObject_WEMH53, NewObject_9MHQV8)
  NewObject_IPT40X1 = rectangle(corner=(0mm, -(L2+W4/2), (-W3/2)-Ssub-Sdir-Sref-L5), y_size=L2+L3+2*W4, z_size=W3)
  NewObject_9HP0Z4 = rectangle(corner=(0mm, -(L2+W4/2), (-W3/2)-Ssub-Sdir-Sref-L5-L4), y_size=L2+L3+2*W4, z_size=W3)
  NewObject_QDASEZ1 = rectangle(corner=(0mm, -(L2+W4/2), (-W3/2)-Ssub-Sdir-Sref-L5-L4), y_size=W4, z_size=L2+1.5*W3)
  NewObject_04U3XR1 = rectangle(corner=(0mm, (L3+W4/2), (-W3/2)-Ssub-Sdir-Sref-L5-L4), y_size=W4, z_size=L2+1.5*W3)
  NewObject_IPT40X1.unite(NewObject_9HP0Z4, NewObject_QDASEZ1, NewObject_04U3XR1)
  NewObject_WEMH54 = rectangle(corner=(0mm, -S5/2, (-W3/2)-sSub-Sdir-Sref-L5), y_size=S5, z_size=W3)
  NewObject_9MHQV9 = rectangle(corner=(0mm, -(S5/2), (-W3/2)-Ssub-Sdir-Sref-L5-L4), y_size=S5, z_size=W3)
  NewObject_IPT40X1.subtract(NewObject_WEMH54, NewObject_9MHQV9)
  NewObject_IPT40X.thicken(1mm)
  NewObject_IPT40X.chamfer(Edges=NewObject_IPT40X.edge(at (0.5, -9, -60.421), at (0.5, -9, -48.421), at (0.5, 28.5, -60.421), at (0.5, 28.5, -48.421)) LeftDistance=W4 RightDistance=W4 ChamferType=Symmetric ChamferAdditionalGeometryInfo{ChamferEdgeGeometryInfo{ChamferEdgeID=354 ChamferEdgeSense ChamferEdgeStart{X=4.8243679e-16mm Y=-9mm Z=-48.421mm} ChamferEdgeEnd{X=1mm Y=-9mm Z=-48.421mm} ChamferEdgeMid{X=0.5mm Y=-9mm Z=-48.421mm} ChamferEdgeMidTangent(1, -6.123234e-17, -1.6081226e-16)} ChamferEdgeGeometryInfo{ChamferEdgeID=355 ChamferEdgeSense ChamferEdgeStart{X=0mm Y=-9mm Z=-60.421mm} ChamferEdgeEnd{X=1mm Y=-9mm Z=-60.421mm} ChamferEdgeMid{X=0.5mm Y=-9mm Z=-60.421mm} ChamferEdgeMidTangent(1, -6.123234e-17, -1.6081226e-16)} ChamferEdgeGeometryInfo{ChamferEdgeID=358 ChamferEdgeSense ChamferEdgeStart{X=2.2962127e-15mm Y=28.5mm Z=-60.421mm} ChamferEdgeEnd{X=1mm Y=28.5mm Z=-60.421mm} ChamferEdgeMid{X=0.5mm Y=28.5mm Z=-60.421mm} ChamferEdgeMidTangent(1, -6.123234e-17, -1.6081226e-16)} ChamferEdgeGeometryInfo{ChamferEdgeID=359 ChamferEdgeSense ChamferEdgeStart{X=2.7786495e-15mm Y=28.5mm Z=-48.421mm} ChamferEdgeEnd{X=1mm Y=28.5mm Z=-48.421mm} ChamferEdgeMid{X=0.5mm Y=28.5mm Z=-48.421mm} ChamferEdgeMidTangent(1, -6.123234e-17, -1.6081226e-16)}})
  NewObject_IPT40X.chamfer(Edges=NewObject_IPT40X.edge(at (0.5, -0.75, -51.421), at (0.5, 0.75, -51.421), at (0.5, -0.75, -57.421), at (0.5, 0.75, -57.421)) LeftDistance=W3 RightDistance=W3 ChamferType=Symmetric ChamferAdditionalGeometryInfo{ChamferEdgeGeometryInfo{ChamferEdgeID=352 ChamferEdgeSense ChamferEdgeStart{X=5.051668e-16mm Y=-0.75mm Z=-51.421mm} ChamferEdgeEnd{X=1mm Y=-0.75mm Z=-51.421mm} ChamferEdgeMid{X=0.5mm Y=-0.75mm Z=-51.421mm} ChamferEdgeMidTangent(1, -6.123234e-17, -1.6081226e-16)} ChamferEdgeGeometryInfo{ChamferEdgeID=357 ChamferEdgeSense ChamferEdgeStart{X=9.876036e-16mm Y=-0.75mm Z=-57.421mm} ChamferEdgeEnd{X=1mm Y=-0.75mm Z=-57.421mm} ChamferEdgeMid{X=0.5mm Y=-0.75mm Z=-57.421mm} ChamferEdgeMidTangent(1, -6.123234e-17, -1.6081226e-16)} ChamferEdgeGeometryInfo{ChamferEdgeID=361 ChamferEdgeSense ChamferEdgeStart{X=5.9701531e-16mm Y=0.75mm Z=-51.421mm} ChamferEdgeEnd{X=1mm Y=0.75mm Z=-51.421mm} ChamferEdgeMid{X=0.5mm Y=0.75mm Z=-51.421mm} ChamferEdgeMidTangent(1, -6.123234e-17, -1.6081226e-16)} ChamferEdgeGeometryInfo{ChamferEdgeID=364 ChamferEdgeSense ChamferEdgeStart{X=1.0794521e-15mm Y=0.75mm Z=-57.421mm} ChamferEdgeEnd{X=1mm Y=0.75mm Z=-57.421mm} ChamferEdgeMid{X=0.5mm Y=0.75mm Z=-57.421mm} ChamferEdgeMidTangent(1, -6.123234e-17, -1.6081226e-16)}})
  NewObject_IPT40X1.intersect(NewObject_IPT40X)
  NewObject_CN9EAS = rectangle(corner=(0mm, -W2/2, -Ssub-Sdir-Sref-L5-L4-L1), y_size=W2, z_size=L1-(W3/2))
  NewObject_ZJX4TP = rectangle(corner=(0mm, -W1/2, -W1-Ssub-Sdir-Sref-L5-L4-L1), y_size=W1, z_size=W1)
  Driver.unite(NewObject_RK7LWU, NewObject_L54683, NewObject_CN9EAS, NewObject_ZJX4TP, NewObject_IPT40X1)
  Driver.subtract(NewObject_C8R3FB, NewObject_JVRP9U, NewObject_1MLUWC)
  port1 = rectangle(corner=(0mm, -W1/2, -W1-Ssub-Sdir-Sref-L5-L4-L1), x_size=-Substrate_Th, y_size=W1)
  RadiatingSurface [vacuum] = region(absolute_offset=44.444444mm on all sides)
boundaries and excitations:
  antennaMetal: Perfect E Objects=[Director, Driver]
  groundMetal: Perfect E Objects=Ground
  AutoOpen1: Radiation Objects=RadiatingSurface
  Driver_T1: Terminal port=1 Edges=Driver.edge(at (0, 0, -76.545)) TerminalResistance=50ohm
  1: Lumped Port Faces=port1.face LumpedPortType=Terminal Impedance=50ohm
  reference conductors: Ground
setups:
  ATK_Solution: HfssDriven Frequency=2.25GHz MaxDeltaS=0.02 MaximumPasses=15 MinimumPasses=1 MinimumConvergedPasses=1 PercentRefinement=30 BasisOrder=1 PortAccuracy=2 DrivenSolverType="Direct Solver" IESolverType=ACA
    sweep FF_Sweep: 1GHz to 3GHz step 0.005GHz; Type=Fast SaveFields
source amplitudes:
  1:1: 1V 0deg
radiation setups:
  3D: Infinite Sphere Theta=0deg..180deg step 2deg Phi=-180deg..180deg step 2deg
reports:
  S11: dB(St(Driver_T1,Driver_T1)) vs Freq on ATK_Solution : FF_Sweep
  Gain Plot 4: dB(GainTotal) vs Theta on ATK_Solution : FF_Sweep, 3D [Phi=90deg Freq=2.25GHz]
  Gain Plot 5: dB(GainTotal) vs Theta on ATK_Solution : FF_Sweep, 3D [Phi=0deg Freq=2.25GHz]
  ATK_OBJ_S11_F0: dB(St(Driver_T1,Driver_T1)) vs Freq on ATK_Solution : FF_Sweep [Freq=2.25GHz]
  ATK_OBJ_Cut_Phi0: dB(GainTotal) vs Theta on ATK_Solution : FF_Sweep, 3D [Phi=0deg Freq=2.25GHz]
  ATK_OBJ_Cut_Phi90: dB(GainTotal) vs Theta on ATK_Solution : FF_Sweep, 3D [Phi=90deg Freq=2.25GHz]
  ATK_OBJ_PeakGain: dB(PeakGain), dB(PeakRealizedGain), FrontToBackRatio vs Freq on ATK_Solution : FF_Sweep [Freq=2.25GHz]

design 3 (HFSS, HFSS Hybrid Terminal Network, model units mm)
options: Allow_Material_Override Save_Adaptive_support_files open_region{BoundaryType=0 OpFreq=2.25GHz}
variables:
  # --Width Dimensions
  Wdir = 3mm
  Wdri = 4.258mm
  W1 = 3mm
  W2 = 6mm
  W3 = 3mm
  W4 = 3mm
  W5 = 3mm
  W6 = 1.5mm
  # --Length Dimensions
  Ldir = 17.528mm
  Ldri = 45.092mm
  L1 = 16.278mm
  L2 = 7.5mm
  L3 = 24mm
  L4 = 9mm
  L5 = 7.5mm
  # --Spacing Dimensions
  Sdir = 17.217mm
  Sref = 20.446mm
  Ssub = 7.5mm
  S5 = 1.5mm
  S6 = 1.5mm
  # --Substrate Dimensions
  Substrate_Th = 3.175mm
  Substrate_Width = 75mm
geometry:
  Substrate [Rogers] = box(corner=(0mm, -Substrate_Width/2, 0mm), size=(-Substrate_Th, Substrate_Width, -(Ssub+Sdir+Sref+L5+L4+L1+2*W1)))
  Ground = rectangle(corner=(-Substrate_Th, -Substrate_Width/2, -(L5+L4+L1+2*W1)-Ssub-Sdir-Sref), y_size=Substrate_Width, z_size=(L5+L4+L1+2*W1))
  Director = rectangle(corner=(0mm, -Ldir/2, (-Wdir/2)-Ssub), y_size=Ldir, z_size=Wdir)
  Driver = rectangle(corner=(0mm, -Ldri/2, (-Wdri/2)-Ssub-Sdir), y_size=Ldri, z_size=Wdri)
  NewObject_C8R3FB = rectangle(corner=(0mm, -S6/2, (-Wdri/2)-Ssub-Sdir), y_size=S6, z_size=Wdri)
  NewObject_RK7LWU = rectangle(corner=(0mm, -(2*W6+S6)/2, -Ssub-Sdir-Sref), y_size=(2*W6+S6), z_size=Sref)
  NewObject_JVRP9U = rectangle(corner=(0mm, -S6/2, -Ssub-Sdir-Sref), y_size=S6, z_size=Sref)
  NewObject_L54683 = rectangle(corner=(0mm, -(2*W5+S5)/2, (W3/2)-sSub-Sdir-Sref-L5), y_size=(2*W5+S5), z_size=L5-(W3/2))
  NewObject_1MLUWC = rectangle(corner=(0mm, -S5/2, -sSub-Sdir-Sref-L5), y_size=S5, z_size=L5)
  NewObject_WEMH53 = rectangle(corner=(0mm, -S5/2, (-W3/2)-sSub-Sdir-Sref-L5), y_size=S5, z_size=W3)
  NewObject_IPT40X = rectangle(corner=(0mm, -(L2+W4/2), (-W3/2)-Ssub-Sdir-Sref-L5), y_size=L2+L3+2*W4, z_size=W3)
  NewObject_9MHQV8 = rectangle(corner=(0mm, -(S5/2), (-W3/2)-Ssub-Sdir-Sref-L5-L4), y_size=S5, z_size=W3)
  NewObject_9HP0Z3 = rectangle(corner=(0mm, -(L2+W4/2), (-W3/2)-Ssub-Sdir-Sref-L5-L4), y_size=L2+L3+2*W4, z_size=W3)
  NewObject_QDASEZ = rectangle(corner=(0mm, -(L2+W4/2), (-W3/2)-Ssub-Sdir-Sref-L5-L4), y_size=W4, z_size=L2+1.5*W3)
  NewObject_04U3XR = rectangle(corner=(0mm, (L3+W4/2), (-W3/2)-Ssub-Sdir-Sref-L5-L4), y_size=W4, z_size=L2+1.5*W3)
  NewObject_IPT40X.unite(NewObject_9HP0Z3, NewObject_QDASEZ, NewObject_04U3XR)
  NewObject_IPT40X.subtract(NewObject_WEMH53, NewObject_9MHQV8)
  NewObject_IPT40X1 = rectangle(corner=(0mm, -(L2+W4/2), (-W3/2)-Ssub-Sdir-Sref-L5), y_size=L2+L3+2*W4, z_size=W3)
  NewObject_9HP0Z4 = rectangle(corner=(0mm, -(L2+W4/2), (-W3/2)-Ssub-Sdir-Sref-L5-L4), y_size=L2+L3+2*W4, z_size=W3)
  NewObject_QDASEZ1 = rectangle(corner=(0mm, -(L2+W4/2), (-W3/2)-Ssub-Sdir-Sref-L5-L4), y_size=W4, z_size=L2+1.5*W3)
  NewObject_04U3XR1 = rectangle(corner=(0mm, (L3+W4/2), (-W3/2)-Ssub-Sdir-Sref-L5-L4), y_size=W4, z_size=L2+1.5*W3)
  NewObject_IPT40X1.unite(NewObject_9HP0Z4, NewObject_QDASEZ1, NewObject_04U3XR1)
  NewObject_WEMH54 = rectangle(corner=(0mm, -S5/2, (-W3/2)-sSub-Sdir-Sref-L5), y_size=S5, z_size=W3)
  NewObject_9MHQV9 = rectangle(corner=(0mm, -(S5/2), (-W3/2)-Ssub-Sdir-Sref-L5-L4), y_size=S5, z_size=W3)
  NewObject_IPT40X1.subtract(NewObject_WEMH54, NewObject_9MHQV9)
  NewObject_IPT40X.thicken(1mm)
  NewObject_IPT40X.chamfer(Edges=NewObject_IPT40X.edge(at (0.5, -9, -63.163), at (0.5, -9, -51.163), at (0.5, 28.5, -63.163), at (0.5, 28.5, -51.163)) LeftDistance=W4 RightDistance=W4 ChamferType=Symmetric ChamferAdditionalGeometryInfo{ChamferEdgeGeometryInfo{ChamferEdgeID=354 ChamferEdgeSense ChamferEdgeStart{X=4.8243679e-16mm Y=-9mm Z=-51.163mm} ChamferEdgeEnd{X=1mm Y=-9mm Z=-51.163mm} ChamferEdgeMid{X=0.5mm Y=-9mm Z=-51.163mm} ChamferEdgeMidTangent(1, -6.123234e-17, -1.6081226e-16)} ChamferEdgeGeometryInfo{ChamferEdgeID=355 ChamferEdgeSense ChamferEdgeStart{X=0mm Y=-9mm Z=-63.163mm} ChamferEdgeEnd{X=1mm Y=-9mm Z=-63.163mm} ChamferEdgeMid{X=0.5mm Y=-9mm Z=-63.163mm} ChamferEdgeMidTangent(1, -6.123234e-17, -1.6081226e-16)} ChamferEdgeGeometryInfo{ChamferEdgeID=358 ChamferEdgeSense ChamferEdgeStart{X=2.2962127e-15mm Y=28.5mm Z=-63.163mm} ChamferEdgeEnd{X=1mm Y=28.5mm Z=-63.163mm} ChamferEdgeMid{X=0.5mm Y=28.5mm Z=-63.163mm} ChamferEdgeMidTangent(1, -6.123234e-17, -1.6081226e-16)} ChamferEdgeGeometryInfo{ChamferEdgeID=359 ChamferEdgeSense ChamferEdgeStart{X=2.7786495e-15mm Y=28.5mm Z=-51.163mm} ChamferEdgeEnd{X=1mm Y=28.5mm Z=-51.163mm} ChamferEdgeMid{X=0.5mm Y=28.5mm Z=-51.163mm} ChamferEdgeMidTangent(1, -6.123234e-17, -1.6081226e-16)}})
  NewObject_IPT40X.chamfer(Edges=NewObject_IPT40X.edge(at (0.5, -0.75, -54.163), at (0.5, 0.75, -54.163), at (0.5, -0.75, -60.163), at (0.5, 0.75, -60.163)) LeftDistance=W3 RightDistance=W3 ChamferType=Symmetric ChamferAdditionalGeometryInfo{ChamferEdgeGeometryInfo{ChamferEdgeID=352 ChamferEdgeSense ChamferEdgeStart{X=5.051668e-16mm Y=-0.75mm Z=-54.163mm} ChamferEdgeEnd{X=1mm Y=-0.75mm Z=-54.163mm} ChamferEdgeMid{X=0.5mm Y=-0.75mm Z=-54.163mm} ChamferEdgeMidTangent(1, -6.123234e-17, -1.6081226e-16)} ChamferEdgeGeometryInfo{ChamferEdgeID=357 ChamferEdgeSense ChamferEdgeStart{X=9.876036e-16mm Y=-0.75mm Z=-60.163mm} ChamferEdgeEnd{X=1mm Y=-0.75mm Z=-60.163mm} ChamferEdgeMid{X=0.5mm Y=-0.75mm Z=-60.163mm} ChamferEdgeMidTangent(1, -6.123234e-17, -1.6081226e-16)} ChamferEdgeGeometryInfo{ChamferEdgeID=361 ChamferEdgeSense ChamferEdgeStart{X=5.9701531e-16mm Y=0.75mm Z=-54.163mm} ChamferEdgeEnd{X=1mm Y=0.75mm Z=-54.163mm} ChamferEdgeMid{X=0.5mm Y=0.75mm Z=-54.163mm} ChamferEdgeMidTangent(1, -6.123234e-17, -1.6081226e-16)} ChamferEdgeGeometryInfo{ChamferEdgeID=364 ChamferEdgeSense ChamferEdgeStart{X=1.0794521e-15mm Y=0.75mm Z=-60.163mm} ChamferEdgeEnd{X=1mm Y=0.75mm Z=-60.163mm} ChamferEdgeMid{X=0.5mm Y=0.75mm Z=-60.163mm} ChamferEdgeMidTangent(1, -6.123234e-17, -1.6081226e-16)}})
  NewObject_IPT40X1.intersect(NewObject_IPT40X)
  NewObject_CN9EAS = rectangle(corner=(0mm, -W2/2, -Ssub-Sdir-Sref-L5-L4-L1), y_size=W2, z_size=L1-(W3/2))
  NewObject_ZJX4TP = rectangle(corner=(0mm, -W1/2, -W1-Ssub-Sdir-Sref-L5-L4-L1), y_size=W1, z_size=W1)
  Driver.unite(NewObject_RK7LWU, NewObject_L54683, NewObject_CN9EAS, NewObject_ZJX4TP, NewObject_IPT40X1)
  Driver.subtract(NewObject_C8R3FB, NewObject_JVRP9U, NewObject_1MLUWC)
  port1 = rectangle(corner=(0mm, -W1/2, -W1-Ssub-Sdir-Sref-L5-L4-L1), x_size=-Substrate_Th, y_size=W1)
  RadiatingSurface [vacuum] = region(absolute_offset=44.444444mm on all sides)
boundaries and excitations:
  antennaMetal: Perfect E Objects=[Director, Driver]
  groundMetal: Perfect E Objects=Ground
  AutoOpen1: Radiation Objects=RadiatingSurface
  Driver_T1: Terminal port=1 Edges=Driver.edge(at (0, 0, -80.941)) TerminalResistance=50ohm
  1: Lumped Port Faces=port1.face LumpedPortType=Terminal Impedance=50ohm
  reference conductors: Ground
setups:
  ATK_Solution: HfssDriven Frequency=2.25GHz MaxDeltaS=0.02 MaximumPasses=15 MinimumPasses=1 MinimumConvergedPasses=1 PercentRefinement=30 BasisOrder=1 PortAccuracy=2 DrivenSolverType="Direct Solver" IESolverType=ACA
    sweep FF_Sweep: 1GHz to 3GHz step 0.005GHz; Type=Fast SaveFields
source amplitudes:
  1:1: 1V 0deg
radiation setups:
  3D: Infinite Sphere Theta=0deg..180deg step 2deg Phi=-180deg..180deg step 2deg
reports:
  S11: dB(St(Driver_T1,Driver_T1)) vs Freq on ATK_Solution : FF_Sweep
  Gain Plot 4: dB(GainTotal) vs Theta on ATK_Solution : FF_Sweep, 3D [Phi=90deg Freq=2.25GHz]
  Gain Plot 5: dB(GainTotal) vs Theta on ATK_Solution : FF_Sweep, 3D [Phi=0deg Freq=2.25GHz]
  ATK_OBJ_S11_F0: dB(St(Driver_T1,Driver_T1)) vs Freq on ATK_Solution : FF_Sweep [Freq=2.25GHz]
  ATK_OBJ_Cut_Phi0: dB(GainTotal) vs Theta on ATK_Solution : FF_Sweep, 3D [Phi=0deg Freq=2.25GHz]
  ATK_OBJ_Cut_Phi90: dB(GainTotal) vs Theta on ATK_Solution : FF_Sweep, 3D [Phi=90deg Freq=2.25GHz]
  ATK_OBJ_PeakGain: dB(PeakGain), dB(PeakRealizedGain), FrontToBackRatio vs Freq on ATK_Solution : FF_Sweep [Freq=2.25GHz]

design 4 (HFSS, HFSS Hybrid Terminal Network, model units mm)
options: Allow_Material_Override Save_Adaptive_support_files open_region{BoundaryType=0 OpFreq=2.25GHz}
variables:
  # --Width Dimensions
  Wdir = 3mm
  Wdri = 2.633mm
  W1 = 3mm
  W2 = 6mm
  W3 = 3mm
  W4 = 3mm
  W5 = 3mm
  W6 = 1.5mm
  # --Length Dimensions
  Ldir = 14.705mm
  Ldri = 45.937mm
  L1 = 14.805mm
  L2 = 7.5mm
  L3 = 24mm
  L4 = 9mm
  L5 = 7.5mm
  # --Spacing Dimensions
  Sdir = 15.135mm
  Sref = 18.412mm
  Ssub = 7.5mm
  S5 = 1.5mm
  S6 = 1.5mm
  # --Substrate Dimensions
  Substrate_Th = 3.175mm
  Substrate_Width = 75mm
geometry:
  Substrate [Rogers] = box(corner=(0mm, -Substrate_Width/2, 0mm), size=(-Substrate_Th, Substrate_Width, -(Ssub+Sdir+Sref+L5+L4+L1+2*W1)))
  Ground = rectangle(corner=(-Substrate_Th, -Substrate_Width/2, -(L5+L4+L1+2*W1)-Ssub-Sdir-Sref), y_size=Substrate_Width, z_size=(L5+L4+L1+2*W1))
  Director = rectangle(corner=(0mm, -Ldir/2, (-Wdir/2)-Ssub), y_size=Ldir, z_size=Wdir)
  Driver = rectangle(corner=(0mm, -Ldri/2, (-Wdri/2)-Ssub-Sdir), y_size=Ldri, z_size=Wdri)
  NewObject_C8R3FB = rectangle(corner=(0mm, -S6/2, (-Wdri/2)-Ssub-Sdir), y_size=S6, z_size=Wdri)
  NewObject_RK7LWU = rectangle(corner=(0mm, -(2*W6+S6)/2, -Ssub-Sdir-Sref), y_size=(2*W6+S6), z_size=Sref)
  NewObject_JVRP9U = rectangle(corner=(0mm, -S6/2, -Ssub-Sdir-Sref), y_size=S6, z_size=Sref)
  NewObject_L54683 = rectangle(corner=(0mm, -(2*W5+S5)/2, (W3/2)-sSub-Sdir-Sref-L5), y_size=(2*W5+S5), z_size=L5-(W3/2))
  NewObject_1MLUWC = rectangle(corner=(0mm, -S5/2, -sSub-Sdir-Sref-L5), y_size=S5, z_size=L5)
  NewObject_WEMH53 = rectangle(corner=(0mm, -S5/2, (-W3/2)-sSub-Sdir-Sref-L5), y_size=S5, z_size=W3)
  NewObject_IPT40X = rectangle(corner=(0mm, -(L2+W4/2), (-W3/2)-Ssub-Sdir-Sref-L5), y_size=L2+L3+2*W4, z_size=W3)
  NewObject_9MHQV8 = rectangle(corner=(0mm, -(S5/2), (-W3/2)-Ssub-Sdir-Sref-L5-L4), y_size=S5, z_size=W3)
  NewObject_9HP0Z3 = rectangle(corner=(0mm, -(L2+W4/2), (-W3/2)-Ssub-Sdir-Sref-L5-L4), y_size=L2+L3+2*W4, z_size=W3)
  NewObject_QDASEZ = rectangle(corner=(0mm, -(L2+W4/2), (-W3/2)-Ssub-Sdir-Sref-L5-L4), y_size=W4, z_size=L2+1.5*W3)
  NewObject_04U3XR = rectangle(corner=(0mm, (L3+W4/2), (-W3/2)-Ssub-Sdir-Sref-L5-L4), y_size=W4, z_size=L2+1.5*W3)
  NewObject_IPT40X.unite(NewObject_9HP0Z3, NewObject_QDASEZ, NewObject_04U3XR)
  NewObject_IPT40X.subtract(NewObject_WEMH53, NewObject_9MHQV8)
  NewObject_IPT40X1 = rectangle(corner=(0mm, -(L2+W4/2), (-W3/2)-Ssub-Sdir-Sref-L5), y_size=L2+L3+2*W4, z_size=W3)
  NewObject_9HP0Z4 = rectangle(corner=(0mm, -(L2+W4/2), (-W3/2)-Ssub-Sdir-Sref-L5-L4), y_size=L2+L3+2*W4, z_size=W3)
  NewObject_QDASEZ1 = rectangle(corner=(0mm, -(L2+W4/2), (-W3/2)-Ssub-Sdir-Sref-L5-L4), y_size=W4, z_size=L2+1.5*W3)
  NewObject_04U3XR1 = rectangle(corner=(0mm, (L3+W4/2), (-W3/2)-Ssub-Sdir-Sref-L5-L4), y_size=W4, z_size=L2+1.5*W3)
  NewObject_IPT40X1.unite(NewObject_9HP0Z4, NewObject_QDASEZ1, NewObject_04U3XR1)
  NewObject_WEMH54 = rectangle(corner=(0mm, -S5/2, (-W3/2)-sSub-Sdir-Sref-L5), y_size=S5, z_size=W3)
  NewObject_9MHQV9 = rectangle(corner=(0mm, -(S5/2), (-W3/2)-Ssub-Sdir-Sref-L5-L4), y_size=S5, z_size=W3)
  NewObject_IPT40X1.subtract(NewObject_WEMH54, NewObject_9MHQV9)
  NewObject_IPT40X.thicken(1mm)
  NewObject_IPT40X.chamfer(Edges=NewObject_IPT40X.edge(at (0.5, -9, -59.047), at (0.5, -9, -47.047), at (0.5, 28.5, -59.047), at (0.5, 28.5, -47.047)) LeftDistance=W4 RightDistance=W4 ChamferType=Symmetric ChamferAdditionalGeometryInfo{ChamferEdgeGeometryInfo{ChamferEdgeID=354 ChamferEdgeSense ChamferEdgeStart{X=4.8243679e-16mm Y=-9mm Z=-47.047mm} ChamferEdgeEnd{X=1mm Y=-9mm Z=-47.047mm} ChamferEdgeMid{X=0.5mm Y=-9mm Z=-47.047mm} ChamferEdgeMidTangent(1, -6.123234e-17, -1.6081226e-16)} ChamferEdgeGeometryInfo{ChamferEdgeID=355 ChamferEdgeSense ChamferEdgeStart{X=0mm Y=-9mm Z=-59.047mm} ChamferEdgeEnd{X=1mm Y=-9mm Z=-59.047mm} ChamferEdgeMid{X=0.5mm Y=-9mm Z=-59.047mm} ChamferEdgeMidTangent(1, -6.123234e-17, -1.6081226e-16)} ChamferEdgeGeometryInfo{ChamferEdgeID=358 ChamferEdgeSense ChamferEdgeStart{X=2.2962127e-15mm Y=28.5mm Z=-59.047mm} ChamferEdgeEnd{X=1mm Y=28.5mm Z=-59.047mm} ChamferEdgeMid{X=0.5mm Y=28.5mm Z=-59.047mm} ChamferEdgeMidTangent(1, -6.123234e-17, -1.6081226e-16)} ChamferEdgeGeometryInfo{ChamferEdgeID=359 ChamferEdgeSense ChamferEdgeStart{X=2.7786495e-15mm Y=28.5mm Z=-47.047mm} ChamferEdgeEnd{X=1mm Y=28.5mm Z=-47.047mm} ChamferEdgeMid{X=0.5mm Y=28.5mm Z=-47.047mm} ChamferEdgeMidTangent(1, -6.123234e-17, -1.6081226e-16)}})
  NewObject_IPT40X.chamfer(Edges=NewObject_IPT40X.edge(at (0.5, -0.75, -50.047), at (0.5, 0.75, -50.047), at (0.5, -0.75, -56.047), at (0.5, 0.75, -56.047)) LeftDistance=W3 RightDistance=W3 ChamferType=Symmetric ChamferAdditionalGeometryInfo{ChamferEdgeGeometryInfo{ChamferEdgeID=352 ChamferEdgeSense ChamferEdgeStart{X=5.051668e-16mm Y=-0.75mm Z=-50.047mm} ChamferEdgeEnd{X=1mm Y=-0.75mm Z=-50.047mm} ChamferEdgeMid{X=0.5mm Y=-0.75mm Z=-50.047mm} ChamferEdgeMidTangent(1, -6.123234e-17, -1.6081226e-16)} ChamferEdgeGeometryInfo{ChamferEdgeID=357 ChamferEdgeSense ChamferEdgeStart{X=9.876036e-16mm Y=-0.75mm Z=-56.047mm} ChamferEdgeEnd{X=1mm Y=-0.75mm Z=-56.047mm} ChamferEdgeMid{X=0.5mm Y=-0.75mm Z=-56.047mm} ChamferEdgeMidTangent(1, -6.123234e-17, -1.6081226e-16)} ChamferEdgeGeometryInfo{ChamferEdgeID=361 ChamferEdgeSense ChamferEdgeStart{X=5.9701531e-16mm Y=0.75mm Z=-50.047mm} ChamferEdgeEnd{X=1mm Y=0.75mm Z=-50.047mm} ChamferEdgeMid{X=0.5mm Y=0.75mm Z=-50.047mm} ChamferEdgeMidTangent(1, -6.123234e-17, -1.6081226e-16)} ChamferEdgeGeometryInfo{ChamferEdgeID=364 ChamferEdgeSense ChamferEdgeStart{X=1.0794521e-15mm Y=0.75mm Z=-56.047mm} ChamferEdgeEnd{X=1mm Y=0.75mm Z=-56.047mm} ChamferEdgeMid{X=0.5mm Y=0.75mm Z=-56.047mm} ChamferEdgeMidTangent(1, -6.123234e-17, -1.6081226e-16)}})
  NewObject_IPT40X1.intersect(NewObject_IPT40X)
  NewObject_CN9EAS = rectangle(corner=(0mm, -W2/2, -Ssub-Sdir-Sref-L5-L4-L1), y_size=W2, z_size=L1-(W3/2))
  NewObject_ZJX4TP = rectangle(corner=(0mm, -W1/2, -W1-Ssub-Sdir-Sref-L5-L4-L1), y_size=W1, z_size=W1)
  Driver.unite(NewObject_RK7LWU, NewObject_L54683, NewObject_CN9EAS, NewObject_ZJX4TP, NewObject_IPT40X1)
  Driver.subtract(NewObject_C8R3FB, NewObject_JVRP9U, NewObject_1MLUWC)
  port1 = rectangle(corner=(0mm, -W1/2, -W1-Ssub-Sdir-Sref-L5-L4-L1), x_size=-Substrate_Th, y_size=W1)
  RadiatingSurface [vacuum] = region(absolute_offset=44.444444mm on all sides)
boundaries and excitations:
  antennaMetal: Perfect E Objects=[Director, Driver]
  groundMetal: Perfect E Objects=Ground
  AutoOpen1: Radiation Objects=RadiatingSurface
  Driver_T1: Terminal port=1 Edges=Driver.edge(at (0, 0, -75.352)) TerminalResistance=50ohm
  1: Lumped Port Faces=port1.face LumpedPortType=Terminal Impedance=50ohm
  reference conductors: Ground
setups:
  ATK_Solution: HfssDriven Frequency=2.25GHz MaxDeltaS=0.02 MaximumPasses=15 MinimumPasses=1 MinimumConvergedPasses=1 PercentRefinement=30 BasisOrder=1 PortAccuracy=2 DrivenSolverType="Direct Solver" IESolverType=ACA
    sweep FF_Sweep: 1GHz to 3GHz step 0.005GHz; Type=Fast SaveFields
source amplitudes:
  1:1: 1V 0deg
radiation setups:
  3D: Infinite Sphere Theta=0deg..180deg step 2deg Phi=-180deg..180deg step 2deg
reports:
  S11: dB(St(Driver_T1,Driver_T1)) vs Freq on ATK_Solution : FF_Sweep
  Gain Plot 4: dB(GainTotal) vs Theta on ATK_Solution : FF_Sweep, 3D [Phi=90deg Freq=2.25GHz]
  Gain Plot 5: dB(GainTotal) vs Theta on ATK_Solution : FF_Sweep, 3D [Phi=0deg Freq=2.25GHz]
  ATK_OBJ_S11_F0: dB(St(Driver_T1,Driver_T1)) vs Freq on ATK_Solution : FF_Sweep [Freq=2.25GHz]
  ATK_OBJ_Cut_Phi0: dB(GainTotal) vs Theta on ATK_Solution : FF_Sweep, 3D [Phi=0deg Freq=2.25GHz]
  ATK_OBJ_Cut_Phi90: dB(GainTotal) vs Theta on ATK_Solution : FF_Sweep, 3D [Phi=90deg Freq=2.25GHz]
  ATK_OBJ_PeakGain: dB(PeakGain), dB(PeakRealizedGain), FrontToBackRatio vs Freq on ATK_Solution : FF_Sweep [Freq=2.25GHz]

design 5 (HFSS, HFSS Hybrid Terminal Network, model units mm)
options: Allow_Material_Override Save_Adaptive_support_files open_region{BoundaryType=0 OpFreq=2.25GHz}
variables:
  # --Width Dimensions
  Wdir = 3mm
  Wdri = 2.932mm
  W1 = 3mm
  W2 = 6mm
  W3 = 3mm
  W4 = 3mm
  W5 = 3mm
  W6 = 1.5mm
  # --Length Dimensions
  Ldir = 17.652mm
  Ldri = 43.934mm
  L1 = 14.72mm
  L2 = 7.5mm
  L3 = 24mm
  L4 = 9mm
  L5 = 7.5mm
  # --Spacing Dimensions
  Sdir = 16.22mm
  Sref = 19.634mm
  Ssub = 7.5mm
  S5 = 1.5mm
  S6 = 1.5mm
  # --Substrate Dimensions
  Substrate_Th = 3.175mm
  Substrate_Width = 75mm
geometry:
  Substrate [Rogers] = box(corner=(0mm, -Substrate_Width/2, 0mm), size=(-Substrate_Th, Substrate_Width, -(Ssub+Sdir+Sref+L5+L4+L1+2*W1)))
  Ground = rectangle(corner=(-Substrate_Th, -Substrate_Width/2, -(L5+L4+L1+2*W1)-Ssub-Sdir-Sref), y_size=Substrate_Width, z_size=(L5+L4+L1+2*W1))
  Director = rectangle(corner=(0mm, -Ldir/2, (-Wdir/2)-Ssub), y_size=Ldir, z_size=Wdir)
  Driver = rectangle(corner=(0mm, -Ldri/2, (-Wdri/2)-Ssub-Sdir), y_size=Ldri, z_size=Wdri)
  NewObject_C8R3FB = rectangle(corner=(0mm, -S6/2, (-Wdri/2)-Ssub-Sdir), y_size=S6, z_size=Wdri)
  NewObject_RK7LWU = rectangle(corner=(0mm, -(2*W6+S6)/2, -Ssub-Sdir-Sref), y_size=(2*W6+S6), z_size=Sref)
  NewObject_JVRP9U = rectangle(corner=(0mm, -S6/2, -Ssub-Sdir-Sref), y_size=S6, z_size=Sref)
  NewObject_L54683 = rectangle(corner=(0mm, -(2*W5+S5)/2, (W3/2)-sSub-Sdir-Sref-L5), y_size=(2*W5+S5), z_size=L5-(W3/2))
  NewObject_1MLUWC = rectangle(corner=(0mm, -S5/2, -sSub-Sdir-Sref-L5), y_size=S5, z_size=L5)
  NewObject_WEMH53 = rectangle(corner=(0mm, -S5/2, (-W3/2)-sSub-Sdir-Sref-L5), y_size=S5, z_size=W3)
  NewObject_IPT40X = rectangle(corner=(0mm, -(L2+W4/2), (-W3/2)-Ssub-Sdir-Sref-L5), y_size=L2+L3+2*W4, z_size=W3)
  NewObject_9MHQV8 = rectangle(corner=(0mm, -(S5/2), (-W3/2)-Ssub-Sdir-Sref-L5-L4), y_size=S5, z_size=W3)
  NewObject_9HP0Z3 = rectangle(corner=(0mm, -(L2+W4/2), (-W3/2)-Ssub-Sdir-Sref-L5-L4), y_size=L2+L3+2*W4, z_size=W3)
  NewObject_QDASEZ = rectangle(corner=(0mm, -(L2+W4/2), (-W3/2)-Ssub-Sdir-Sref-L5-L4), y_size=W4, z_size=L2+1.5*W3)
  NewObject_04U3XR = rectangle(corner=(0mm, (L3+W4/2), (-W3/2)-Ssub-Sdir-Sref-L5-L4), y_size=W4, z_size=L2+1.5*W3)
  NewObject_IPT40X.unite(NewObject_9HP0Z3, NewObject_QDASEZ, NewObject_04U3XR)
  NewObject_IPT40X.subtract(NewObject_WEMH53, NewObject_9MHQV8)
  NewObject_IPT40X1 = rectangle(corner=(0mm, -(L2+W4/2), (-W3/2)-Ssub-Sdir-Sref-L5), y_size=L2+L3+2*W4, z_size=W3)
  NewObject_9HP0Z4 = rectangle(corner=(0mm, -(L2+W4/2), (-W3/2)-Ssub-Sdir-Sref-L5-L4), y_size=L2+L3+2*W4, z_size=W3)
  NewObject_QDASEZ1 = rectangle(corner=(0mm, -(L2+W4/2), (-W3/2)-Ssub-Sdir-Sref-L5-L4), y_size=W4, z_size=L2+1.5*W3)
  NewObject_04U3XR1 = rectangle(corner=(0mm, (L3+W4/2), (-W3/2)-Ssub-Sdir-Sref-L5-L4), y_size=W4, z_size=L2+1.5*W3)
  NewObject_IPT40X1.unite(NewObject_9HP0Z4, NewObject_QDASEZ1, NewObject_04U3XR1)
  NewObject_WEMH54 = rectangle(corner=(0mm, -S5/2, (-W3/2)-sSub-Sdir-Sref-L5), y_size=S5, z_size=W3)
  NewObject_9MHQV9 = rectangle(corner=(0mm, -(S5/2), (-W3/2)-Ssub-Sdir-Sref-L5-L4), y_size=S5, z_size=W3)
  NewObject_IPT40X1.subtract(NewObject_WEMH54, NewObject_9MHQV9)
  NewObject_IPT40X.thicken(1mm)
  NewObject_IPT40X.chamfer(Edges=NewObject_IPT40X.edge(at (0.5, -9, -61.354), at (0.5, -9, -49.354), at (0.5, 28.5, -61.354), at (0.5, 28.5, -49.354)) LeftDistance=W4 RightDistance=W4 ChamferType=Symmetric ChamferAdditionalGeometryInfo{ChamferEdgeGeometryInfo{ChamferEdgeID=354 ChamferEdgeSense ChamferEdgeStart{X=4.8243679e-16mm Y=-9mm Z=-49.354mm} ChamferEdgeEnd{X=1mm Y=-9mm Z=-49.354mm} ChamferEdgeMid{X=0.5mm Y=-9mm Z=-49.354mm} ChamferEdgeMidTangent(1, -6.123234e-17, -1.6081226e-16)} ChamferEdgeGeometryInfo{ChamferEdgeID=355 ChamferEdgeSense ChamferEdgeStart{X=0mm Y=-9mm Z=-61.354mm} ChamferEdgeEnd{X=1mm Y=-9mm Z=-61.354mm} ChamferEdgeMid{X=0.5mm Y=-9mm Z=-61.354mm} ChamferEdgeMidTangent(1, -6.123234e-17, -1.6081226e-16)} ChamferEdgeGeometryInfo{ChamferEdgeID=358 ChamferEdgeSense ChamferEdgeStart{X=2.2962127e-15mm Y=28.5mm Z=-61.354mm} ChamferEdgeEnd{X=1mm Y=28.5mm Z=-61.354mm} ChamferEdgeMid{X=0.5mm Y=28.5mm Z=-61.354mm} ChamferEdgeMidTangent(1, -6.123234e-17, -1.6081226e-16)} ChamferEdgeGeometryInfo{ChamferEdgeID=359 ChamferEdgeSense ChamferEdgeStart{X=2.7786495e-15mm Y=28.5mm Z=-49.354mm} ChamferEdgeEnd{X=1mm Y=28.5mm Z=-49.354mm} ChamferEdgeMid{X=0.5mm Y=28.5mm Z=-49.354mm} ChamferEdgeMidTangent(1, -6.123234e-17, -1.6081226e-16)}})
  NewObject_IPT40X.chamfer(Edges=NewObject_IPT40X.edge(at (0.5, -0.75, -52.354), at (0.5, 0.75, -52.354), at (0.5, -0.75, -58.354), at (0.5, 0.75, -58.354)) LeftDistance=W3 RightDistance=W3 ChamferType=Symmetric ChamferAdditionalGeometryInfo{ChamferEdgeGeometryInfo{ChamferEdgeID=352 ChamferEdgeSense ChamferEdgeStart{X=5.051668e-16mm Y=-0.75mm Z=-52.354mm} ChamferEdgeEnd{X=1mm Y=-0.75mm Z=-52.354mm} ChamferEdgeMid{X=0.5mm Y=-0.75mm Z=-52.354mm} ChamferEdgeMidTangent(1, -6.123234e-17, -1.6081226e-16)} ChamferEdgeGeometryInfo{ChamferEdgeID=357 ChamferEdgeSense ChamferEdgeStart{X=9.876036e-16mm Y=-0.75mm Z=-58.354mm} ChamferEdgeEnd{X=1mm Y=-0.75mm Z=-58.354mm} ChamferEdgeMid{X=0.5mm Y=-0.75mm Z=-58.354mm} ChamferEdgeMidTangent(1, -6.123234e-17, -1.6081226e-16)} ChamferEdgeGeometryInfo{ChamferEdgeID=361 ChamferEdgeSense ChamferEdgeStart{X=5.9701531e-16mm Y=0.75mm Z=-52.354mm} ChamferEdgeEnd{X=1mm Y=0.75mm Z=-52.354mm} ChamferEdgeMid{X=0.5mm Y=0.75mm Z=-52.354mm} ChamferEdgeMidTangent(1, -6.123234e-17, -1.6081226e-16)} ChamferEdgeGeometryInfo{ChamferEdgeID=364 ChamferEdgeSense ChamferEdgeStart{X=1.0794521e-15mm Y=0.75mm Z=-58.354mm} ChamferEdgeEnd{X=1mm Y=0.75mm Z=-58.354mm} ChamferEdgeMid{X=0.5mm Y=0.75mm Z=-58.354mm} ChamferEdgeMidTangent(1, -6.123234e-17, -1.6081226e-16)}})
  NewObject_IPT40X1.intersect(NewObject_IPT40X)
  NewObject_CN9EAS = rectangle(corner=(0mm, -W2/2, -Ssub-Sdir-Sref-L5-L4-L1), y_size=W2, z_size=L1-(W3/2))
  NewObject_ZJX4TP = rectangle(corner=(0mm, -W1/2, -W1-Ssub-Sdir-Sref-L5-L4-L1), y_size=W1, z_size=W1)
  Driver.unite(NewObject_RK7LWU, NewObject_L54683, NewObject_CN9EAS, NewObject_ZJX4TP, NewObject_IPT40X1)
  Driver.subtract(NewObject_C8R3FB, NewObject_JVRP9U, NewObject_1MLUWC)
  port1 = rectangle(corner=(0mm, -W1/2, -W1-Ssub-Sdir-Sref-L5-L4-L1), x_size=-Substrate_Th, y_size=W1)
  RadiatingSurface [vacuum] = region(absolute_offset=44.444444mm on all sides)
boundaries and excitations:
  antennaMetal: Perfect E Objects=[Director, Driver]
  groundMetal: Perfect E Objects=Ground
  AutoOpen1: Radiation Objects=RadiatingSurface
  Driver_T1: Terminal port=1 Edges=Driver.edge(at (0, 0, -77.574)) TerminalResistance=50ohm
  1: Lumped Port Faces=port1.face LumpedPortType=Terminal Impedance=50ohm
  reference conductors: Ground
setups:
  ATK_Solution: HfssDriven Frequency=2.25GHz MaxDeltaS=0.02 MaximumPasses=15 MinimumPasses=1 MinimumConvergedPasses=1 PercentRefinement=30 BasisOrder=1 PortAccuracy=2 DrivenSolverType="Direct Solver" IESolverType=ACA
    sweep FF_Sweep: 1GHz to 3GHz step 0.005GHz; Type=Fast SaveFields
source amplitudes:
  1:1: 1V 0deg
radiation setups:
  3D: Infinite Sphere Theta=0deg..180deg step 2deg Phi=-180deg..180deg step 2deg
reports:
  S11: dB(St(Driver_T1,Driver_T1)) vs Freq on ATK_Solution : FF_Sweep
  Gain Plot 4: dB(GainTotal) vs Theta on ATK_Solution : FF_Sweep, 3D [Phi=90deg Freq=2.25GHz]
  Gain Plot 5: dB(GainTotal) vs Theta on ATK_Solution : FF_Sweep, 3D [Phi=0deg Freq=2.25GHz]
  ATK_OBJ_S11_F0: dB(St(Driver_T1,Driver_T1)) vs Freq on ATK_Solution : FF_Sweep [Freq=2.25GHz]
  ATK_OBJ_Cut_Phi0: dB(GainTotal) vs Theta on ATK_Solution : FF_Sweep, 3D [Phi=0deg Freq=2.25GHz]
  ATK_OBJ_Cut_Phi90: dB(GainTotal) vs Theta on ATK_Solution : FF_Sweep, 3D [Phi=90deg Freq=2.25GHz]
  ATK_OBJ_PeakGain: dB(PeakGain), dB(PeakRealizedGain), FrontToBackRatio vs Freq on ATK_Solution : FF_Sweep [Freq=2.25GHz]

design 6 (HFSS, HFSS Hybrid Terminal Network, model units mm)
options: Allow_Material_Override Save_Adaptive_support_files open_region{BoundaryType=0 OpFreq=2.25GHz}
variables:
  # --Width Dimensions
  Wdir = 3mm
  Wdri = 3.292mm
  W1 = 3mm
  W2 = 6mm
  W3 = 3mm
  W4 = 3mm
  W5 = 3mm
  W6 = 1.5mm
  # --Length Dimensions
  Ldir = 17.764mm
  Ldri = 43.965mm
  L1 = 18.493mm
  L2 = 7.5mm
  L3 = 24mm
  L4 = 9mm
  L5 = 7.5mm
  # --Spacing Dimensions
  Sdir = 17.576mm
  Sref = 20.84mm
  Ssub = 7.5mm
  S5 = 1.5mm
  S6 = 1.5mm
  # --Substrate Dimensions
  Substrate_Th = 3.175mm
  Substrate_Width = 75mm
geometry:
  Substrate [Rogers] = box(corner=(0mm, -Substrate_Width/2, 0mm), size=(-Substrate_Th, Substrate_Width, -(Ssub+Sdir+Sref+L5+L4+L1+2*W1)))
  Ground = rectangle(corner=(-Substrate_Th, -Substrate_Width/2, -(L5+L4+L1+2*W1)-Ssub-Sdir-Sref), y_size=Substrate_Width, z_size=(L5+L4+L1+2*W1))
  Director = rectangle(corner=(0mm, -Ldir/2, (-Wdir/2)-Ssub), y_size=Ldir, z_size=Wdir)
  Driver = rectangle(corner=(0mm, -Ldri/2, (-Wdri/2)-Ssub-Sdir), y_size=Ldri, z_size=Wdri)
  NewObject_C8R3FB = rectangle(corner=(0mm, -S6/2, (-Wdri/2)-Ssub-Sdir), y_size=S6, z_size=Wdri)
  NewObject_RK7LWU = rectangle(corner=(0mm, -(2*W6+S6)/2, -Ssub-Sdir-Sref), y_size=(2*W6+S6), z_size=Sref)
  NewObject_JVRP9U = rectangle(corner=(0mm, -S6/2, -Ssub-Sdir-Sref), y_size=S6, z_size=Sref)
  NewObject_L54683 = rectangle(corner=(0mm, -(2*W5+S5)/2, (W3/2)-sSub-Sdir-Sref-L5), y_size=(2*W5+S5), z_size=L5-(W3/2))
  NewObject_1MLUWC = rectangle(corner=(0mm, -S5/2, -sSub-Sdir-Sref-L5), y_size=S5, z_size=L5)
  NewObject_WEMH53 = rectangle(corner=(0mm, -S5/2, (-W3/2)-sSub-Sdir-Sref-L5), y_size=S5, z_size=W3)
  NewObject_IPT40X = rectangle(corner=(0mm, -(L2+W4/2), (-W3/2)-Ssub-Sdir-Sref-L5), y_size=L2+L3+2*W4, z_size=W3)
  NewObject_9MHQV8 = rectangle(corner=(0mm, -(S5/2), (-W3/2)-Ssub-Sdir-Sref-L5-L4), y_size=S5, z_size=W3)
  NewObject_9HP0Z3 = rectangle(corner=(0mm, -(L2+W4/2), (-W3/2)-Ssub-Sdir-Sref-L5-L4), y_size=L2+L3+2*W4, z_size=W3)
  NewObject_QDASEZ = rectangle(corner=(0mm, -(L2+W4/2), (-W3/2)-Ssub-Sdir-Sref-L5-L4), y_size=W4, z_size=L2+1.5*W3)
  NewObject_04U3XR = rectangle(corner=(0mm, (L3+W4/2), (-W3/2)-Ssub-Sdir-Sref-L5-L4), y_size=W4, z_size=L2+1.5*W3)
  NewObject_IPT40X.unite(NewObject_9HP0Z3, NewObject_QDASEZ, NewObject_04U3XR)
  NewObject_IPT40X.subtract(NewObject_WEMH53, NewObject_9MHQV8)
  NewObject_IPT40X1 = rectangle(corner=(0mm, -(L2+W4/2), (-W3/2)-Ssub-Sdir-Sref-L5), y_size=L2+L3+2*W4, z_size=W3)
  NewObject_9HP0Z4 = rectangle(corner=(0mm, -(L2+W4/2), (-W3/2)-Ssub-Sdir-Sref-L5-L4), y_size=L2+L3+2*W4, z_size=W3)
  NewObject_QDASEZ1 = rectangle(corner=(0mm, -(L2+W4/2), (-W3/2)-Ssub-Sdir-Sref-L5-L4), y_size=W4, z_size=L2+1.5*W3)
  NewObject_04U3XR1 = rectangle(corner=(0mm, (L3+W4/2), (-W3/2)-Ssub-Sdir-Sref-L5-L4), y_size=W4, z_size=L2+1.5*W3)
  NewObject_IPT40X1.unite(NewObject_9HP0Z4, NewObject_QDASEZ1, NewObject_04U3XR1)
  NewObject_WEMH54 = rectangle(corner=(0mm, -S5/2, (-W3/2)-sSub-Sdir-Sref-L5), y_size=S5, z_size=W3)
  NewObject_9MHQV9 = rectangle(corner=(0mm, -(S5/2), (-W3/2)-Ssub-Sdir-Sref-L5-L4), y_size=S5, z_size=W3)
  NewObject_IPT40X1.subtract(NewObject_WEMH54, NewObject_9MHQV9)
  NewObject_IPT40X.thicken(1mm)
  NewObject_IPT40X.chamfer(Edges=NewObject_IPT40X.edge(at (0.5, -9, -63.916), at (0.5, -9, -51.916), at (0.5, 28.5, -63.916), at (0.5, 28.5, -51.916)) LeftDistance=W4 RightDistance=W4 ChamferType=Symmetric ChamferAdditionalGeometryInfo{ChamferEdgeGeometryInfo{ChamferEdgeID=354 ChamferEdgeSense ChamferEdgeStart{X=4.8243679e-16mm Y=-9mm Z=-51.916mm} ChamferEdgeEnd{X=1mm Y=-9mm Z=-51.916mm} ChamferEdgeMid{X=0.5mm Y=-9mm Z=-51.916mm} ChamferEdgeMidTangent(1, -6.123234e-17, -1.6081226e-16)} ChamferEdgeGeometryInfo{ChamferEdgeID=355 ChamferEdgeSense ChamferEdgeStart{X=0mm Y=-9mm Z=-63.916mm} ChamferEdgeEnd{X=1mm Y=-9mm Z=-63.916mm} ChamferEdgeMid{X=0.5mm Y=-9mm Z=-63.916mm} ChamferEdgeMidTangent(1, -6.123234e-17, -1.6081226e-16)} ChamferEdgeGeometryInfo{ChamferEdgeID=358 ChamferEdgeSense ChamferEdgeStart{X=2.2962127e-15mm Y=28.5mm Z=-63.916mm} ChamferEdgeEnd{X=1mm Y=28.5mm Z=-63.916mm} ChamferEdgeMid{X=0.5mm Y=28.5mm Z=-63.916mm} ChamferEdgeMidTangent(1, -6.123234e-17, -1.6081226e-16)} ChamferEdgeGeometryInfo{ChamferEdgeID=359 ChamferEdgeSense ChamferEdgeStart{X=2.7786495e-15mm Y=28.5mm Z=-51.916mm} ChamferEdgeEnd{X=1mm Y=28.5mm Z=-51.916mm} ChamferEdgeMid{X=0.5mm Y=28.5mm Z=-51.916mm} ChamferEdgeMidTangent(1, -6.123234e-17, -1.6081226e-16)}})
  NewObject_IPT40X.chamfer(Edges=NewObject_IPT40X.edge(at (0.5, -0.75, -54.916), at (0.5, 0.75, -54.916), at (0.5, -0.75, -60.916), at (0.5, 0.75, -60.916)) LeftDistance=W3 RightDistance=W3 ChamferType=Symmetric ChamferAdditionalGeometryInfo{ChamferEdgeGeometryInfo{ChamferEdgeID=352 ChamferEdgeSense ChamferEdgeStart{X=5.051668e-16mm Y=-0.75mm Z=-54.916mm} ChamferEdgeEnd{X=1mm Y=-0.75mm Z=-54.916mm} ChamferEdgeMid{X=0.5mm Y=-0.75mm Z=-54.916mm} ChamferEdgeMidTangent(1, -6.123234e-17, -1.6081226e-16)} ChamferEdgeGeometryInfo{ChamferEdgeID=357 ChamferEdgeSense ChamferEdgeStart{X=9.876036e-16mm Y=-0.75mm Z=-60.916mm} ChamferEdgeEnd{X=1mm Y=-0.75mm Z=-60.916mm} ChamferEdgeMid{X=0.5mm Y=-0.75mm Z=-60.916mm} ChamferEdgeMidTangent(1, -6.123234e-17, -1.6081226e-16)} ChamferEdgeGeometryInfo{ChamferEdgeID=361 ChamferEdgeSense ChamferEdgeStart{X=5.9701531e-16mm Y=0.75mm Z=-54.916mm} ChamferEdgeEnd{X=1mm Y=0.75mm Z=-54.916mm} ChamferEdgeMid{X=0.5mm Y=0.75mm Z=-54.916mm} ChamferEdgeMidTangent(1, -6.123234e-17, -1.6081226e-16)} ChamferEdgeGeometryInfo{ChamferEdgeID=364 ChamferEdgeSense ChamferEdgeStart{X=1.0794521e-15mm Y=0.75mm Z=-60.916mm} ChamferEdgeEnd{X=1mm Y=0.75mm Z=-60.916mm} ChamferEdgeMid{X=0.5mm Y=0.75mm Z=-60.916mm} ChamferEdgeMidTangent(1, -6.123234e-17, -1.6081226e-16)}})
  NewObject_IPT40X1.intersect(NewObject_IPT40X)
  NewObject_CN9EAS = rectangle(corner=(0mm, -W2/2, -Ssub-Sdir-Sref-L5-L4-L1), y_size=W2, z_size=L1-(W3/2))
  NewObject_ZJX4TP = rectangle(corner=(0mm, -W1/2, -W1-Ssub-Sdir-Sref-L5-L4-L1), y_size=W1, z_size=W1)
  Driver.unite(NewObject_RK7LWU, NewObject_L54683, NewObject_CN9EAS, NewObject_ZJX4TP, NewObject_IPT40X1)
  Driver.subtract(NewObject_C8R3FB, NewObject_JVRP9U, NewObject_1MLUWC)
  port1 = rectangle(corner=(0mm, -W1/2, -W1-Ssub-Sdir-Sref-L5-L4-L1), x_size=-Substrate_Th, y_size=W1)
  RadiatingSurface [vacuum] = region(absolute_offset=44.444444mm on all sides)
boundaries and excitations:
  antennaMetal: Perfect E Objects=[Director, Driver]
  groundMetal: Perfect E Objects=Ground
  AutoOpen1: Radiation Objects=RadiatingSurface
  Driver_T1: Terminal port=1 Edges=Driver.edge(at (0, 0, -83.909)) TerminalResistance=50ohm
  1: Lumped Port Faces=port1.face LumpedPortType=Terminal Impedance=50ohm
  reference conductors: Ground
setups:
  ATK_Solution: HfssDriven Frequency=2.25GHz MaxDeltaS=0.02 MaximumPasses=15 MinimumPasses=1 MinimumConvergedPasses=1 PercentRefinement=30 BasisOrder=1 PortAccuracy=2 DrivenSolverType="Direct Solver" IESolverType=ACA
    sweep FF_Sweep: 1GHz to 3GHz step 0.005GHz; Type=Fast SaveFields
source amplitudes:
  1:1: 1V 0deg
radiation setups:
  3D: Infinite Sphere Theta=0deg..180deg step 2deg Phi=-180deg..180deg step 2deg
reports:
  S11: dB(St(Driver_T1,Driver_T1)) vs Freq on ATK_Solution : FF_Sweep
  Gain Plot 4: dB(GainTotal) vs Theta on ATK_Solution : FF_Sweep, 3D [Phi=90deg Freq=2.25GHz]
  Gain Plot 5: dB(GainTotal) vs Theta on ATK_Solution : FF_Sweep, 3D [Phi=0deg Freq=2.25GHz]
  ATK_OBJ_S11_F0: dB(St(Driver_T1,Driver_T1)) vs Freq on ATK_Solution : FF_Sweep [Freq=2.25GHz]
  ATK_OBJ_Cut_Phi0: dB(GainTotal) vs Theta on ATK_Solution : FF_Sweep, 3D [Phi=0deg Freq=2.25GHz]
  ATK_OBJ_Cut_Phi90: dB(GainTotal) vs Theta on ATK_Solution : FF_Sweep, 3D [Phi=90deg Freq=2.25GHz]
  ATK_OBJ_PeakGain: dB(PeakGain), dB(PeakRealizedGain), FrontToBackRatio vs Freq on ATK_Solution : FF_Sweep [Freq=2.25GHz]
